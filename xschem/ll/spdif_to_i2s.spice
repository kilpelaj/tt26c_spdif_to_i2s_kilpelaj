* NGSPICE file created from spdif_to_i2s.ext - technology: sky130A

* Black-box entry subcircuit for sky130_fd_sc_hd__fill_1 abstract view
.subckt sky130_fd_sc_hd__fill_1 VGND VNB VPB VPWR
.ends

* Black-box entry subcircuit for sky130_fd_sc_hd__a21oi_1 abstract view
.subckt sky130_fd_sc_hd__a21oi_1 A1 A2 B1 VGND VNB VPB VPWR Y
.ends

* Black-box entry subcircuit for sky130_fd_sc_hd__o41ai_1 abstract view
.subckt sky130_fd_sc_hd__o41ai_1 A1 A2 A3 A4 B1 VGND VNB VPB VPWR Y
.ends

* Black-box entry subcircuit for sky130_fd_sc_hd__dlygate4sd3_1 abstract view
.subckt sky130_fd_sc_hd__dlygate4sd3_1 A VGND VNB VPB VPWR X
.ends

* Black-box entry subcircuit for sky130_fd_sc_hd__decap_12 abstract view
.subckt sky130_fd_sc_hd__decap_12 VGND VNB VPB VPWR
.ends

* Black-box entry subcircuit for sky130_fd_sc_hd__fill_2 abstract view
.subckt sky130_fd_sc_hd__fill_2 VGND VNB VPB VPWR
.ends

* Black-box entry subcircuit for sky130_fd_sc_hd__decap_3 abstract view
.subckt sky130_fd_sc_hd__decap_3 VGND VNB VPB VPWR
.ends

* Black-box entry subcircuit for sky130_fd_sc_hd__o21ai_0 abstract view
.subckt sky130_fd_sc_hd__o21ai_0 A1 A2 B1 VGND VNB VPB VPWR Y
.ends

* Black-box entry subcircuit for sky130_fd_sc_hd__clkdlybuf4s25_1 abstract view
.subckt sky130_fd_sc_hd__clkdlybuf4s25_1 A VGND VNB VPB VPWR X
.ends

* Black-box entry subcircuit for sky130_fd_sc_hd__decap_6 abstract view
.subckt sky130_fd_sc_hd__decap_6 VGND VNB VPB VPWR
.ends

* Black-box entry subcircuit for sky130_fd_sc_hd__o211a_1 abstract view
.subckt sky130_fd_sc_hd__o211a_1 A1 A2 B1 C1 VGND VNB VPB VPWR X
.ends

* Black-box entry subcircuit for sky130_fd_sc_hd__clkdlybuf4s50_1 abstract view
.subckt sky130_fd_sc_hd__clkdlybuf4s50_1 A VGND VNB VPB VPWR X
.ends

* Black-box entry subcircuit for sky130_fd_sc_hd__dfrtp_1 abstract view
.subckt sky130_fd_sc_hd__dfrtp_1 CLK D RESET_B VGND VNB VPB VPWR Q
.ends

* Black-box entry subcircuit for sky130_fd_sc_hd__maj3_1 abstract view
.subckt sky130_fd_sc_hd__maj3_1 A B C VGND VNB VPB VPWR X
.ends

* Black-box entry subcircuit for sky130_fd_sc_hd__o22a_1 abstract view
.subckt sky130_fd_sc_hd__o22a_1 A1 A2 B1 B2 VGND VNB VPB VPWR X
.ends

* Black-box entry subcircuit for sky130_fd_sc_hd__decap_8 abstract view
.subckt sky130_fd_sc_hd__decap_8 VGND VNB VPB VPWR
.ends

* Black-box entry subcircuit for sky130_fd_sc_hd__tapvpwrvgnd_1 abstract view
.subckt sky130_fd_sc_hd__tapvpwrvgnd_1 VGND VPWR
.ends

* Black-box entry subcircuit for sky130_fd_sc_hd__inv_1 abstract view
.subckt sky130_fd_sc_hd__inv_1 A VGND VNB VPB VPWR Y
.ends

* Black-box entry subcircuit for sky130_fd_sc_hd__nand2_1 abstract view
.subckt sky130_fd_sc_hd__nand2_1 A B VGND VNB VPB VPWR Y
.ends

* Black-box entry subcircuit for sky130_fd_sc_hd__xor2_1 abstract view
.subckt sky130_fd_sc_hd__xor2_1 A B VGND VNB VPB VPWR X
.ends

* Black-box entry subcircuit for sky130_fd_sc_hd__dfstp_2 abstract view
.subckt sky130_fd_sc_hd__dfstp_2 CLK D SET_B VGND VNB VPB VPWR Q
.ends

* Black-box entry subcircuit for sky130_fd_sc_hd__xnor2_1 abstract view
.subckt sky130_fd_sc_hd__xnor2_1 A B VGND VNB VPB VPWR Y
.ends

* Black-box entry subcircuit for sky130_fd_sc_hd__o32a_1 abstract view
.subckt sky130_fd_sc_hd__o32a_1 A1 A2 A3 B1 B2 VGND VNB VPB VPWR X
.ends

* Black-box entry subcircuit for sky130_fd_sc_hd__a21boi_0 abstract view
.subckt sky130_fd_sc_hd__a21boi_0 A1 A2 B1_N VGND VNB VPB VPWR Y
.ends

* Black-box entry subcircuit for sky130_fd_sc_hd__mux2_1 abstract view
.subckt sky130_fd_sc_hd__mux2_1 A0 A1 S VGND VNB VPB VPWR X
.ends

* Black-box entry subcircuit for sky130_fd_sc_hd__nor2_1 abstract view
.subckt sky130_fd_sc_hd__nor2_1 A B VGND VNB VPB VPWR Y
.ends

* Black-box entry subcircuit for sky130_fd_sc_hd__mux2i_1 abstract view
.subckt sky130_fd_sc_hd__mux2i_1 A0 A1 S VGND VNB VPB VPWR Y
.ends

* Black-box entry subcircuit for sky130_fd_sc_hd__nor3_1 abstract view
.subckt sky130_fd_sc_hd__nor3_1 A B C VGND VNB VPB VPWR Y
.ends

* Black-box entry subcircuit for sky130_fd_sc_hd__decap_4 abstract view
.subckt sky130_fd_sc_hd__decap_4 VGND VNB VPB VPWR
.ends

* Black-box entry subcircuit for sky130_fd_sc_hd__nor4_1 abstract view
.subckt sky130_fd_sc_hd__nor4_1 A B C D VGND VNB VPB VPWR Y
.ends

* Black-box entry subcircuit for sky130_fd_sc_hd__nand3_1 abstract view
.subckt sky130_fd_sc_hd__nand3_1 A B C VGND VNB VPB VPWR Y
.ends

* Black-box entry subcircuit for sky130_fd_sc_hd__a22o_1 abstract view
.subckt sky130_fd_sc_hd__a22o_1 A1 A2 B1 B2 VGND VNB VPB VPWR X
.ends

* Black-box entry subcircuit for sky130_fd_sc_hd__dfrtp_2 abstract view
.subckt sky130_fd_sc_hd__dfrtp_2 CLK D RESET_B VGND VNB VPB VPWR Q
.ends

* Black-box entry subcircuit for sky130_fd_sc_hd__a41oi_1 abstract view
.subckt sky130_fd_sc_hd__a41oi_1 A1 A2 A3 A4 B1 VGND VNB VPB VPWR Y
.ends

* Black-box entry subcircuit for sky130_fd_sc_hd__a211oi_1 abstract view
.subckt sky130_fd_sc_hd__a211oi_1 A1 A2 B1 C1 VGND VNB VPB VPWR Y
.ends

* Black-box entry subcircuit for sky130_fd_sc_hd__buf_4 abstract view
.subckt sky130_fd_sc_hd__buf_4 A VGND VNB VPB VPWR X
.ends

* Black-box entry subcircuit for sky130_fd_sc_hd__and2_0 abstract view
.subckt sky130_fd_sc_hd__and2_0 A B VGND VNB VPB VPWR X
.ends

* Black-box entry subcircuit for sky130_fd_sc_hd__and3_1 abstract view
.subckt sky130_fd_sc_hd__and3_1 A B C VGND VNB VPB VPWR X
.ends

* Black-box entry subcircuit for sky130_fd_sc_hd__o31ai_1 abstract view
.subckt sky130_fd_sc_hd__o31ai_1 A1 A2 A3 B1 VGND VNB VPB VPWR Y
.ends

* Black-box entry subcircuit for sky130_fd_sc_hd__o22ai_1 abstract view
.subckt sky130_fd_sc_hd__o22ai_1 A1 A2 B1 B2 VGND VNB VPB VPWR Y
.ends

* Black-box entry subcircuit for sky130_fd_sc_hd__a32o_1 abstract view
.subckt sky130_fd_sc_hd__a32o_1 A1 A2 A3 B1 B2 VGND VNB VPB VPWR X
.ends

* Black-box entry subcircuit for sky130_fd_sc_hd__o311ai_1 abstract view
.subckt sky130_fd_sc_hd__o311ai_1 A1 A2 A3 B1 C1 VGND VNB VPB VPWR Y
.ends

* Black-box entry subcircuit for sky130_fd_sc_hd__a22oi_1 abstract view
.subckt sky130_fd_sc_hd__a22oi_1 A1 A2 B1 B2 VGND VNB VPB VPWR Y
.ends

* Black-box entry subcircuit for sky130_fd_sc_hd__nor2b_1 abstract view
.subckt sky130_fd_sc_hd__nor2b_1 A B_N VGND VNB VPB VPWR Y
.ends

* Black-box entry subcircuit for sky130_fd_sc_hd__a31oi_1 abstract view
.subckt sky130_fd_sc_hd__a31oi_1 A1 A2 A3 B1 VGND VNB VPB VPWR Y
.ends

* Black-box entry subcircuit for sky130_fd_sc_hd__a221oi_1 abstract view
.subckt sky130_fd_sc_hd__a221oi_1 A1 A2 B1 B2 C1 VGND VNB VPB VPWR Y
.ends

* Black-box entry subcircuit for sky130_fd_sc_hd__a21o_1 abstract view
.subckt sky130_fd_sc_hd__a21o_1 A1 A2 B1 VGND VNB VPB VPWR X
.ends

* Black-box entry subcircuit for sky130_fd_sc_hd__or4_1 abstract view
.subckt sky130_fd_sc_hd__or4_1 A B C D VGND VNB VPB VPWR X
.ends

* Black-box entry subcircuit for sky130_fd_sc_hd__o2bb2ai_1 abstract view
.subckt sky130_fd_sc_hd__o2bb2ai_1 A1_N A2_N B1 B2 VGND VNB VPB VPWR Y
.ends

* Black-box entry subcircuit for sky130_fd_sc_hd__and3b_1 abstract view
.subckt sky130_fd_sc_hd__and3b_1 A_N B C VGND VNB VPB VPWR X
.ends

* Black-box entry subcircuit for sky130_fd_sc_hd__clkbuf_16 abstract view
.subckt sky130_fd_sc_hd__clkbuf_16 A VGND VNB VPB VPWR X
.ends

* Black-box entry subcircuit for sky130_fd_sc_hd__a311oi_1 abstract view
.subckt sky130_fd_sc_hd__a311oi_1 A1 A2 A3 B1 C1 VGND VNB VPB VPWR Y
.ends

* Black-box entry subcircuit for sky130_fd_sc_hd__xor3_1 abstract view
.subckt sky130_fd_sc_hd__xor3_1 A B C VGND VNB VPB VPWR X
.ends

* Black-box entry subcircuit for sky130_fd_sc_hd__a31o_1 abstract view
.subckt sky130_fd_sc_hd__a31o_1 A1 A2 A3 B1 VGND VNB VPB VPWR X
.ends

* Black-box entry subcircuit for sky130_fd_sc_hd__clkbuf_1 abstract view
.subckt sky130_fd_sc_hd__clkbuf_1 A VGND VNB VPB VPWR X
.ends

* Black-box entry subcircuit for sky130_fd_sc_hd__nand4_1 abstract view
.subckt sky130_fd_sc_hd__nand4_1 A B C D VGND VNB VPB VPWR Y
.ends

* Black-box entry subcircuit for sky130_fd_sc_hd__o221ai_1 abstract view
.subckt sky130_fd_sc_hd__o221ai_1 A1 A2 B1 B2 C1 VGND VNB VPB VPWR Y
.ends

* Black-box entry subcircuit for sky130_fd_sc_hd__or2_0 abstract view
.subckt sky130_fd_sc_hd__or2_0 A B VGND VNB VPB VPWR X
.ends

* Black-box entry subcircuit for sky130_fd_sc_hd__clkinv_2 abstract view
.subckt sky130_fd_sc_hd__clkinv_2 A VGND VNB VPB VPWR Y
.ends

* Black-box entry subcircuit for sky130_fd_sc_hd__inv_8 abstract view
.subckt sky130_fd_sc_hd__inv_8 A VGND VNB VPB VPWR Y
.ends

* Black-box entry subcircuit for sky130_fd_sc_hd__o21a_1 abstract view
.subckt sky130_fd_sc_hd__o21a_1 A1 A2 B1 VGND VNB VPB VPWR X
.ends

* Black-box entry subcircuit for sky130_fd_sc_hd__nand2b_1 abstract view
.subckt sky130_fd_sc_hd__nand2b_1 A_N B VGND VNB VPB VPWR Y
.ends

* Black-box entry subcircuit for sky130_fd_sc_hd__inv_4 abstract view
.subckt sky130_fd_sc_hd__inv_4 A VGND VNB VPB VPWR Y
.ends

* Black-box entry subcircuit for sky130_fd_sc_hd__o31a_1 abstract view
.subckt sky130_fd_sc_hd__o31a_1 A1 A2 A3 B1 VGND VNB VPB VPWR X
.ends

* Black-box entry subcircuit for sky130_fd_sc_hd__a2bb2oi_1 abstract view
.subckt sky130_fd_sc_hd__a2bb2oi_1 A1_N A2_N B1 B2 VGND VNB VPB VPWR Y
.ends

* Black-box entry subcircuit for sky130_fd_sc_hd__bufinv_16 abstract view
.subckt sky130_fd_sc_hd__bufinv_16 A VGND VNB VPB VPWR Y
.ends

* Black-box entry subcircuit for sky130_fd_sc_hd__clkbuf_8 abstract view
.subckt sky130_fd_sc_hd__clkbuf_8 A VGND VNB VPB VPWR X
.ends

* Black-box entry subcircuit for sky130_fd_sc_hd__o21bai_1 abstract view
.subckt sky130_fd_sc_hd__o21bai_1 A1 A2 B1_N VGND VNB VPB VPWR Y
.ends

* Black-box entry subcircuit for sky130_fd_sc_hd__inv_6 abstract view
.subckt sky130_fd_sc_hd__inv_6 A VGND VNB VPB VPWR Y
.ends

* Black-box entry subcircuit for sky130_fd_sc_hd__inv_16 abstract view
.subckt sky130_fd_sc_hd__inv_16 A VGND VNB VPB VPWR Y
.ends

* Black-box entry subcircuit for sky130_fd_sc_hd__buf_1 abstract view
.subckt sky130_fd_sc_hd__buf_1 A VGND VNB VPB VPWR X
.ends

* Black-box entry subcircuit for sky130_fd_sc_hd__o2111a_1 abstract view
.subckt sky130_fd_sc_hd__o2111a_1 A1 A2 B1 C1 D1 VGND VNB VPB VPWR X
.ends

* Black-box entry subcircuit for sky130_fd_sc_hd__a211o_1 abstract view
.subckt sky130_fd_sc_hd__a211o_1 A1 A2 B1 C1 VGND VNB VPB VPWR X
.ends

* Black-box entry subcircuit for sky130_fd_sc_hd__or3_1 abstract view
.subckt sky130_fd_sc_hd__or3_1 A B C VGND VNB VPB VPWR X
.ends

* Black-box entry subcircuit for sky130_fd_sc_hd__o2111ai_1 abstract view
.subckt sky130_fd_sc_hd__o2111ai_1 A1 A2 B1 C1 D1 VGND VNB VPB VPWR Y
.ends

* Black-box entry subcircuit for sky130_fd_sc_hd__clkbuf_2 abstract view
.subckt sky130_fd_sc_hd__clkbuf_2 A VGND VNB VPB VPWR X
.ends

* Black-box entry subcircuit for sky130_fd_sc_hd__o21ba_1 abstract view
.subckt sky130_fd_sc_hd__o21ba_1 A1 A2 B1_N VGND VNB VPB VPWR X
.ends

* Black-box entry subcircuit for sky130_fd_sc_hd__nand4b_1 abstract view
.subckt sky130_fd_sc_hd__nand4b_1 A_N B C D VGND VNB VPB VPWR Y
.ends

* Black-box entry subcircuit for sky130_fd_sc_hd__o41ai_2 abstract view
.subckt sky130_fd_sc_hd__o41ai_2 A1 A2 A3 A4 B1 VGND VNB VPB VPWR Y
.ends

* Black-box entry subcircuit for sky130_fd_sc_hd__o211ai_1 abstract view
.subckt sky130_fd_sc_hd__o211ai_1 A1 A2 B1 C1 VGND VNB VPB VPWR Y
.ends

* Black-box entry subcircuit for sky130_fd_sc_hd__nand3b_1 abstract view
.subckt sky130_fd_sc_hd__nand3b_1 A_N B C VGND VNB VPB VPWR Y
.ends

* Black-box entry subcircuit for sky130_fd_sc_hd__o41a_1 abstract view
.subckt sky130_fd_sc_hd__o41a_1 A1 A2 A3 A4 B1 VGND VNB VPB VPWR X
.ends

* Black-box entry subcircuit for sky130_fd_sc_hd__o32ai_1 abstract view
.subckt sky130_fd_sc_hd__o32ai_1 A1 A2 A3 B1 B2 VGND VNB VPB VPWR Y
.ends

* Black-box entry subcircuit for sky130_fd_sc_hd__clkbuf_4 abstract view
.subckt sky130_fd_sc_hd__clkbuf_4 A VGND VNB VPB VPWR X
.ends

* Black-box entry subcircuit for sky130_fd_sc_hd__buf_2 abstract view
.subckt sky130_fd_sc_hd__buf_2 A VGND VNB VPB VPWR X
.ends

* Black-box entry subcircuit for sky130_fd_sc_hd__a211oi_2 abstract view
.subckt sky130_fd_sc_hd__a211oi_2 A1 A2 B1 C1 VGND VNB VPB VPWR Y
.ends

* Black-box entry subcircuit for sky130_fd_sc_hd__a221o_1 abstract view
.subckt sky130_fd_sc_hd__a221o_1 A1 A2 B1 B2 C1 VGND VNB VPB VPWR X
.ends

* Black-box entry subcircuit for sky130_fd_sc_hd__nor4_2 abstract view
.subckt sky130_fd_sc_hd__nor4_2 A B C D VGND VNB VPB VPWR Y
.ends

* Black-box entry subcircuit for sky130_fd_sc_hd__a32oi_1 abstract view
.subckt sky130_fd_sc_hd__a32oi_1 A1 A2 A3 B1 B2 VGND VNB VPB VPWR Y
.ends

* Black-box entry subcircuit for sky130_fd_sc_hd__a311o_1 abstract view
.subckt sky130_fd_sc_hd__a311o_1 A1 A2 A3 B1 C1 VGND VNB VPB VPWR X
.ends

* Black-box entry subcircuit for sky130_fd_sc_hd__a2111oi_0 abstract view
.subckt sky130_fd_sc_hd__a2111oi_0 A1 A2 B1 C1 D1 VGND VNB VPB VPWR Y
.ends

* Black-box entry subcircuit for sky130_fd_sc_hd__a222oi_1 abstract view
.subckt sky130_fd_sc_hd__a222oi_1 A1 A2 B1 B2 C1 C2 VGND VNB VPB VPWR Y
.ends

.subckt spdif_to_i2s VGND VPWR block_start clk i2s_bclk i2s_sd i2s_ws locked mute
+ pwm_out rst_n spdif_in
XFILLER_39_288 VGND VGND VPWR VPWR sky130_fd_sc_hd__fill_1
X_2037_ _1225_/Y _2038_/B _2036_/Y VGND VGND VPWR VPWR _2600_/D sky130_fd_sc_hd__a21oi_1
X_2106_ _2414_/Q _2415_/Q _2114_/C _2102_/D _2416_/Q VGND VGND VPWR VPWR _2106_/Y
+ sky130_fd_sc_hd__o41ai_1
XFILLER_22_155 VGND VGND VPWR VPWR sky130_fd_sc_hd__fill_1
Xhold340 _2507_/Q VGND VGND VPWR VPWR hold340/X sky130_fd_sc_hd__dlygate4sd3_1
Xhold351 _1980_/Y VGND VGND VPWR VPWR _2560_/D sky130_fd_sc_hd__dlygate4sd3_1
Xhold362 _2610_/Q VGND VGND VPWR VPWR hold362/X sky130_fd_sc_hd__dlygate4sd3_1
Xhold373 _2509_/Q VGND VGND VPWR VPWR hold373/X sky130_fd_sc_hd__dlygate4sd3_1
XFILLER_60_228 VGND VGND VPWR VPWR sky130_fd_sc_hd__fill_1
XFILLER_45_225 VGND VGND VPWR VPWR sky130_fd_sc_hd__fill_1
XFILLER_13_122 VGND VGND VPWR VPWR sky130_fd_sc_hd__decap_12
XFILLER_26_85 VGND VGND VPWR VPWR sky130_fd_sc_hd__fill_2
XFILLER_42_40 VGND VGND VPWR VPWR sky130_fd_sc_hd__decap_12
XPHY_EDGE_ROW_39_Left_110 VGND VGND VPWR VPWR sky130_fd_sc_hd__decap_3
XFILLER_13_166 VGND VGND VPWR VPWR sky130_fd_sc_hd__fill_2
XFILLER_13_177 VGND VGND VPWR VPWR sky130_fd_sc_hd__fill_2
X_1270_ _1472_/A _1269_/Y _1266_/Y VGND VGND VPWR VPWR _1274_/A sky130_fd_sc_hd__o21ai_0
Xwire29 wire29/A VGND VGND VPWR VPWR wire29/X sky130_fd_sc_hd__clkdlybuf4s25_1
XFILLER_51_217 VGND VGND VPWR VPWR sky130_fd_sc_hd__decap_6
X_1606_ _2101_/A _2052_/B _2080_/C _1605_/Y VGND VGND VPWR VPWR _1606_/X sky130_fd_sc_hd__o211a_1
Xfanout138 _2424_/Q VGND VGND VPWR VPWR _2187_/B sky130_fd_sc_hd__clkdlybuf4s50_1
X_2586_ clkload8/A _2586_/D load_slew170/X VGND VGND VPWR VPWR _2586_/Q sky130_fd_sc_hd__dfrtp_1
Xfanout127 _2430_/Q VGND VGND VPWR VPWR _2257_/B sky130_fd_sc_hd__clkdlybuf4s50_1
X_1399_ _2242_/A _2257_/B wire36/X VGND VGND VPWR VPWR _1442_/C sky130_fd_sc_hd__maj3_1
Xfanout105 _2485_/Q VGND VGND VPWR VPWR _2318_/A sky130_fd_sc_hd__clkdlybuf4s50_1
X_1468_ _1374_/A _1374_/B _2373_/B VGND VGND VPWR VPWR _2615_/D sky130_fd_sc_hd__a21oi_1
Xfanout149 fanout156/X VGND VGND VPWR VPWR fanout149/X sky130_fd_sc_hd__clkdlybuf4s50_1
X_1537_ _2632_/Q _1487_/Y _1535_/Y _1536_/X VGND VGND VPWR VPWR _1537_/X sky130_fd_sc_hd__o22a_1
Xfanout116 _2273_/A VGND VGND VPWR VPWR _2272_/A sky130_fd_sc_hd__clkdlybuf4s50_1
XFILLER_27_225 VGND VGND VPWR VPWR sky130_fd_sc_hd__decap_8
XFILLER_12_54 VGND VGND VPWR VPWR sky130_fd_sc_hd__decap_12
XTAP_TAPCELL_ROW_5_173 VGND VPWR sky130_fd_sc_hd__tapvpwrvgnd_1
XFILLER_53_50 VGND VGND VPWR VPWR sky130_fd_sc_hd__decap_6
X_2440_ clkload5/A _2440_/D load_slew162/X VGND VGND VPWR VPWR _2440_/Q sky130_fd_sc_hd__dfrtp_1
X_1253_ _2501_/Q VGND VGND VPWR VPWR _1814_/A sky130_fd_sc_hd__inv_1
X_1322_ _1690_/A _1322_/B VGND VGND VPWR VPWR _1322_/Y sky130_fd_sc_hd__nand2_1
XFILLER_5_184 VGND VGND VPWR VPWR sky130_fd_sc_hd__fill_2
X_2371_ _2440_/Q _2439_/Q VGND VGND VPWR VPWR _2371_/X sky130_fd_sc_hd__xor2_1
XTAP_TAPCELL_ROW_19_242 VGND VPWR sky130_fd_sc_hd__tapvpwrvgnd_1
XFILLER_32_272 VGND VGND VPWR VPWR sky130_fd_sc_hd__fill_1
XFILLER_59_103 VGND VGND VPWR VPWR sky130_fd_sc_hd__decap_8
X_2569_ clkload6/A _2569_/D load_slew147/X VGND VGND VPWR VPWR _2569_/Q sky130_fd_sc_hd__dfrtp_1
XFILLER_59_169 VGND VGND VPWR VPWR sky130_fd_sc_hd__fill_2
XFILLER_15_217 VGND VGND VPWR VPWR sky130_fd_sc_hd__fill_1
XFILLER_23_53 VGND VGND VPWR VPWR sky130_fd_sc_hd__decap_3
XFILLER_0_57 VGND VGND VPWR VPWR sky130_fd_sc_hd__decap_8
XFILLER_64_93 VGND VGND VPWR VPWR sky130_fd_sc_hd__fill_1
X_1871_ _1933_/B _1869_/Y _1870_/Y VGND VGND VPWR VPWR _2523_/D sky130_fd_sc_hd__o21ai_0
XFILLER_9_11 VGND VGND VPWR VPWR sky130_fd_sc_hd__fill_1
X_1940_ _1942_/B _1938_/Y _1939_/Y VGND VGND VPWR VPWR _2546_/D sky130_fd_sc_hd__o21ai_0
X_2423_ _2633_/CLK _2423_/D fanout187/X VGND VGND VPWR VPWR _2423_/Q sky130_fd_sc_hd__dfstp_2
XPHY_EDGE_ROW_24_Left_95 VGND VGND VPWR VPWR sky130_fd_sc_hd__decap_3
XFILLER_56_139 VGND VGND VPWR VPWR sky130_fd_sc_hd__fill_1
X_1305_ _1305_/A _1305_/B VGND VGND VPWR VPWR _1305_/Y sky130_fd_sc_hd__xnor2_1
X_2285_ _2136_/Y _2271_/Y _2284_/Y _2136_/A hold339/X VGND VGND VPWR VPWR _2431_/D
+ sky130_fd_sc_hd__o32a_1
X_2354_ _2348_/A _2350_/B _2348_/B VGND VGND VPWR VPWR _2356_/B sky130_fd_sc_hd__a21boi_0
X_1236_ _2448_/Q VGND VGND VPWR VPWR _1236_/Y sky130_fd_sc_hd__inv_1
XFILLER_20_253 VGND VGND VPWR VPWR sky130_fd_sc_hd__decap_12
XTAP_TAPCELL_ROW_22_259 VGND VPWR sky130_fd_sc_hd__tapvpwrvgnd_1
XFILLER_70_197 VGND VGND VPWR VPWR sky130_fd_sc_hd__decap_3
XFILLER_11_264 VGND VGND VPWR VPWR sky130_fd_sc_hd__decap_12
XTAP_TAPCELL_ROW_13_215 VGND VPWR sky130_fd_sc_hd__tapvpwrvgnd_1
XFILLER_59_93 VGND VGND VPWR VPWR sky130_fd_sc_hd__decap_3
X_2070_ _2460_/Q hold359/X _2074_/S VGND VGND VPWR VPWR _2402_/D sky130_fd_sc_hd__mux2_1
XFILLER_46_161 VGND VGND VPWR VPWR sky130_fd_sc_hd__fill_1
XTAP_TAPCELL_ROW_36_329 VGND VPWR sky130_fd_sc_hd__tapvpwrvgnd_1
X_1785_ _1785_/A _2050_/B VGND VGND VPWR VPWR _1785_/Y sky130_fd_sc_hd__nor2_1
XFILLER_61_197 VGND VGND VPWR VPWR sky130_fd_sc_hd__decap_12
X_1854_ _2517_/Q _2591_/Q _1932_/S VGND VGND VPWR VPWR _1854_/Y sky130_fd_sc_hd__mux2i_1
X_1923_ _2540_/Q _2566_/Q _1947_/S VGND VGND VPWR VPWR _1923_/Y sky130_fd_sc_hd__mux2i_1
X_2406_ _2607_/CLK _2406_/D fanout176/X VGND VGND VPWR VPWR _2406_/Q sky130_fd_sc_hd__dfrtp_1
Xfanout7 _2076_/S VGND VGND VPWR VPWR _2054_/S sky130_fd_sc_hd__clkdlybuf4s50_1
X_2199_ _2477_/Q _2200_/B VGND VGND VPWR VPWR _2199_/Y sky130_fd_sc_hd__nand2_1
X_2268_ _2173_/A _2256_/Y _1466_/B VGND VGND VPWR VPWR _2268_/Y sky130_fd_sc_hd__a21oi_1
X_2337_ _2321_/A _2323_/B _2320_/Y VGND VGND VPWR VPWR _2339_/B sky130_fd_sc_hd__o21ai_0
X_1219_ _2409_/Q VGND VGND VPWR VPWR _1219_/Y sky130_fd_sc_hd__inv_1
XFILLER_52_197 VGND VGND VPWR VPWR sky130_fd_sc_hd__fill_1
XTAP_TAPCELL_ROW_50_398 VGND VPWR sky130_fd_sc_hd__tapvpwrvgnd_1
XFILLER_4_249 VGND VGND VPWR VPWR sky130_fd_sc_hd__decap_3
XFILLER_20_43 VGND VGND VPWR VPWR sky130_fd_sc_hd__decap_12
XFILLER_29_30 VGND VGND VPWR VPWR sky130_fd_sc_hd__decap_6
XFILLER_61_61 VGND VGND VPWR VPWR sky130_fd_sc_hd__fill_1
XTAP_TAPCELL_ROW_41_354 VGND VPWR sky130_fd_sc_hd__tapvpwrvgnd_1
X_1570_ _1573_/C _1570_/B _1977_/B VGND VGND VPWR VPWR _2619_/D sky130_fd_sc_hd__nor3_1
XFILLER_3_260 VGND VGND VPWR VPWR sky130_fd_sc_hd__fill_2
XFILLER_66_267 VGND VGND VPWR VPWR sky130_fd_sc_hd__fill_2
X_2053_ _2443_/Q hold355/X _2054_/S VGND VGND VPWR VPWR _2385_/D sky130_fd_sc_hd__mux2_1
X_2122_ _2122_/A _2122_/B VGND VGND VPWR VPWR _2130_/C sky130_fd_sc_hd__nor2_1
XFILLER_13_3 VGND VGND VPWR VPWR sky130_fd_sc_hd__decap_4
XTAP_TAPCELL_ROW_64_468 VGND VPWR sky130_fd_sc_hd__tapvpwrvgnd_1
XFILLER_34_153 VGND VGND VPWR VPWR sky130_fd_sc_hd__fill_1
XTAP_TAPCELL_ROW_32_310 VGND VPWR sky130_fd_sc_hd__tapvpwrvgnd_1
X_1768_ _2119_/C _1768_/B VGND VGND VPWR VPWR _1770_/A sky130_fd_sc_hd__nor2_1
X_1837_ _1837_/A _1909_/B VGND VGND VPWR VPWR _1837_/Y sky130_fd_sc_hd__nand2_1
X_1906_ _1906_/A _1909_/B VGND VGND VPWR VPWR _1906_/Y sky130_fd_sc_hd__nand2_1
X_1699_ _2289_/A _1699_/B VGND VGND VPWR VPWR _1700_/B sky130_fd_sc_hd__nand2_1
XFILLER_57_278 VGND VGND VPWR VPWR sky130_fd_sc_hd__fill_2
XTAP_TAPCELL_ROW_55_424 VGND VPWR sky130_fd_sc_hd__tapvpwrvgnd_1
XPHY_EDGE_ROW_11_Left_82 VGND VGND VPWR VPWR sky130_fd_sc_hd__decap_3
XFILLER_15_76 VGND VGND VPWR VPWR sky130_fd_sc_hd__fill_1
XFILLER_63_237 VGND VGND VPWR VPWR sky130_fd_sc_hd__decap_4
XFILLER_48_234 VGND VGND VPWR VPWR sky130_fd_sc_hd__decap_8
XFILLER_16_120 VGND VGND VPWR VPWR sky130_fd_sc_hd__decap_12
X_1622_ _1230_/Y _1621_/Y _1624_/S VGND VGND VPWR VPWR _2454_/D sky130_fd_sc_hd__mux2i_1
XFILLER_39_223 VGND VGND VPWR VPWR sky130_fd_sc_hd__fill_1
XFILLER_39_201 VGND VGND VPWR VPWR sky130_fd_sc_hd__fill_1
X_1484_ _1484_/A _1484_/B VGND VGND VPWR VPWR _1530_/B sky130_fd_sc_hd__nand2_1
X_1553_ _2332_/A _2485_/Q _2484_/Q _2483_/Q VGND VGND VPWR VPWR _1556_/B sky130_fd_sc_hd__nor4_1
X_2036_ _2036_/A _2038_/B VGND VGND VPWR VPWR _2036_/Y sky130_fd_sc_hd__nor2_1
X_2105_ _2105_/A _2108_/B _2108_/C VGND VGND VPWR VPWR _2105_/Y sky130_fd_sc_hd__nand3_1
Xhold374 _2506_/Q VGND VGND VPWR VPWR hold374/X sky130_fd_sc_hd__dlygate4sd3_1
Xhold352 _2500_/Q VGND VGND VPWR VPWR _1804_/A sky130_fd_sc_hd__dlygate4sd3_1
Xhold330 _2504_/Q VGND VGND VPWR VPWR _1822_/A sky130_fd_sc_hd__dlygate4sd3_1
Xhold341 _2487_/Q VGND VGND VPWR VPWR _1708_/A sky130_fd_sc_hd__dlygate4sd3_1
Xhold363 _2401_/Q VGND VGND VPWR VPWR hold363/X sky130_fd_sc_hd__dlygate4sd3_1
XFILLER_45_215 VGND VGND VPWR VPWR sky130_fd_sc_hd__fill_1
XFILLER_13_134 VGND VGND VPWR VPWR sky130_fd_sc_hd__decap_6
XFILLER_42_52 VGND VGND VPWR VPWR sky130_fd_sc_hd__decap_8
XFILLER_3_57 VGND VGND VPWR VPWR sky130_fd_sc_hd__fill_2
XFILLER_51_207 VGND VGND VPWR VPWR sky130_fd_sc_hd__decap_6
XFILLER_44_270 VGND VGND VPWR VPWR sky130_fd_sc_hd__fill_1
X_2585_ _2606_/CLK _2585_/D fanout173/X VGND VGND VPWR VPWR _2585_/Q sky130_fd_sc_hd__dfrtp_1
X_1536_ _2632_/Q _1487_/Y _1488_/Y _2631_/Q VGND VGND VPWR VPWR _1536_/X sky130_fd_sc_hd__a22o_1
X_1605_ _2082_/A _2412_/Q _2413_/Q VGND VGND VPWR VPWR _1605_/Y sky130_fd_sc_hd__nand3_1
Xfanout139 _2424_/Q VGND VGND VPWR VPWR _1431_/B sky130_fd_sc_hd__clkdlybuf4s50_1
Xfanout128 _2429_/Q VGND VGND VPWR VPWR _2242_/B sky130_fd_sc_hd__clkdlybuf4s50_1
X_1398_ _2242_/A _2255_/A VGND VGND VPWR VPWR _1422_/B sky130_fd_sc_hd__xor2_1
Xfanout106 _2482_/Q VGND VGND VPWR VPWR _2274_/A sky130_fd_sc_hd__clkdlybuf4s50_1
X_1467_ _1467_/A _1467_/B VGND VGND VPWR VPWR _2373_/B sky130_fd_sc_hd__nand2_1
Xfanout117 _2316_/A VGND VGND VPWR VPWR _2273_/A sky130_fd_sc_hd__clkdlybuf4s50_1
X_2019_ _1234_/Y _2034_/B _2018_/Y VGND VGND VPWR VPWR _2591_/D sky130_fd_sc_hd__a21oi_1
XFILLER_27_237 VGND VGND VPWR VPWR sky130_fd_sc_hd__decap_12
XFILLER_27_259 VGND VGND VPWR VPWR sky130_fd_sc_hd__decap_12
XFILLER_12_66 VGND VGND VPWR VPWR sky130_fd_sc_hd__decap_4
Xhold193 _2616_/Q VGND VGND VPWR VPWR _2612_/D sky130_fd_sc_hd__dlygate4sd3_1
XTAP_TAPCELL_ROW_5_174 VGND VPWR sky130_fd_sc_hd__tapvpwrvgnd_1
XTAP_TAPCELL_ROW_28_287 VGND VPWR sky130_fd_sc_hd__tapvpwrvgnd_1
XFILLER_52_7 VGND VGND VPWR VPWR sky130_fd_sc_hd__fill_1
XFILLER_5_163 VGND VGND VPWR VPWR sky130_fd_sc_hd__fill_1
XFILLER_5_130 VGND VGND VPWR VPWR sky130_fd_sc_hd__fill_2
X_1252_ _2500_/Q VGND VGND VPWR VPWR _1813_/A sky130_fd_sc_hd__inv_1
X_1321_ _1692_/A _1321_/B VGND VGND VPWR VPWR _1321_/Y sky130_fd_sc_hd__nor2_1
X_2370_ _1467_/A _2368_/Y _2369_/Y _2439_/Q VGND VGND VPWR VPWR _2439_/D sky130_fd_sc_hd__a22o_1
XFILLER_17_281 VGND VGND VPWR VPWR sky130_fd_sc_hd__decap_8
XTAP_TAPCELL_ROW_19_243 VGND VPWR sky130_fd_sc_hd__tapvpwrvgnd_1
XFILLER_24_229 VGND VGND VPWR VPWR sky130_fd_sc_hd__decap_12
X_2499_ _2634_/CLK _2499_/D fanout182/X VGND VGND VPWR VPWR _2499_/Q sky130_fd_sc_hd__dfrtp_1
XPHY_EDGE_ROW_58_Left_129 VGND VGND VPWR VPWR sky130_fd_sc_hd__decap_3
X_1519_ _1519_/A _1523_/A VGND VGND VPWR VPWR _1519_/Y sky130_fd_sc_hd__nor2_1
X_2568_ _2592_/CLK _2568_/D load_slew147/X VGND VGND VPWR VPWR _2568_/Q sky130_fd_sc_hd__dfrtp_1
XPHY_EDGE_ROW_12_Right_12 VGND VGND VPWR VPWR sky130_fd_sc_hd__decap_3
XFILLER_67_181 VGND VGND VPWR VPWR sky130_fd_sc_hd__fill_1
XPHY_EDGE_ROW_21_Right_21 VGND VGND VPWR VPWR sky130_fd_sc_hd__decap_3
XPHY_EDGE_ROW_67_Left_138 VGND VGND VPWR VPWR sky130_fd_sc_hd__decap_3
XFILLER_15_229 VGND VGND VPWR VPWR sky130_fd_sc_hd__fill_1
XPHY_EDGE_ROW_30_Right_30 VGND VGND VPWR VPWR sky130_fd_sc_hd__decap_3
X_1870_ _1870_/A _1933_/B VGND VGND VPWR VPWR _1870_/Y sky130_fd_sc_hd__nand2_1
XFILLER_43_3 VGND VGND VPWR VPWR sky130_fd_sc_hd__decap_6
X_2353_ fanout3/X _2345_/Y _2352_/Y _2327_/B _2351_/A VGND VGND VPWR VPWR _2436_/D
+ sky130_fd_sc_hd__o32a_1
X_2422_ clkload5/A _2422_/D load_slew162/X VGND VGND VPWR VPWR locked sky130_fd_sc_hd__dfrtp_2
X_1304_ _1289_/A _1289_/B _1289_/C _1295_/A _1303_/Y VGND VGND VPWR VPWR _1305_/B
+ sky130_fd_sc_hd__a41oi_1
X_2284_ _2283_/B _2282_/X _2283_/Y _2173_/A VGND VGND VPWR VPWR _2284_/Y sky130_fd_sc_hd__a211oi_1
X_1235_ _2449_/Q VGND VGND VPWR VPWR _1235_/Y sky130_fd_sc_hd__inv_1
XTAP_TAPCELL_ROW_47_382 VGND VPWR sky130_fd_sc_hd__tapvpwrvgnd_1
X_1999_ hold323/X _2404_/Q _1999_/S VGND VGND VPWR VPWR _2579_/D sky130_fd_sc_hd__mux2_1
XFILLER_20_265 VGND VGND VPWR VPWR sky130_fd_sc_hd__decap_4
XFILLER_70_121 VGND VGND VPWR VPWR sky130_fd_sc_hd__decap_8
XFILLER_70_176 VGND VGND VPWR VPWR sky130_fd_sc_hd__decap_12
XFILLER_11_276 VGND VGND VPWR VPWR sky130_fd_sc_hd__decap_4
XTAP_TAPCELL_ROW_13_216 VGND VPWR sky130_fd_sc_hd__tapvpwrvgnd_1
XFILLER_7_258 VGND VGND VPWR VPWR sky130_fd_sc_hd__fill_1
XFILLER_61_154 VGND VGND VPWR VPWR sky130_fd_sc_hd__fill_1
Xload_slew64 _1917_/S VGND VGND VPWR VPWR _1932_/S sky130_fd_sc_hd__buf_4
X_1922_ _1924_/B _1920_/Y _1921_/Y VGND VGND VPWR VPWR _1922_/Y sky130_fd_sc_hd__o21ai_0
X_1784_ _2050_/B _1782_/Y _1783_/Y VGND VGND VPWR VPWR _2492_/D sky130_fd_sc_hd__a21oi_1
X_1853_ _1945_/B _1851_/Y _1852_/Y VGND VGND VPWR VPWR _2517_/D sky130_fd_sc_hd__o21ai_0
XFILLER_69_232 VGND VGND VPWR VPWR sky130_fd_sc_hd__fill_1
X_2405_ clkload9/A _2405_/D load_slew177/X VGND VGND VPWR VPWR _2405_/Q sky130_fd_sc_hd__dfrtp_1
X_2336_ _2336_/A _2336_/B VGND VGND VPWR VPWR _2339_/A sky130_fd_sc_hd__xor2_1
X_2198_ _2198_/A _2198_/B VGND VGND VPWR VPWR _2200_/B sky130_fd_sc_hd__xnor2_1
XFILLER_37_162 VGND VGND VPWR VPWR sky130_fd_sc_hd__fill_2
X_2267_ _2255_/A _2283_/B _2266_/Y VGND VGND VPWR VPWR _2267_/Y sky130_fd_sc_hd__o21ai_0
X_1218_ _2410_/Q VGND VGND VPWR VPWR _1218_/Y sky130_fd_sc_hd__inv_1
XTAP_TAPCELL_ROW_50_399 VGND VPWR sky130_fd_sc_hd__tapvpwrvgnd_1
XFILLER_20_55 VGND VGND VPWR VPWR sky130_fd_sc_hd__decap_8
XFILLER_43_121 VGND VGND VPWR VPWR sky130_fd_sc_hd__decap_3
XFILLER_28_195 VGND VGND VPWR VPWR sky130_fd_sc_hd__fill_1
XTAP_TAPCELL_ROW_41_355 VGND VPWR sky130_fd_sc_hd__tapvpwrvgnd_1
XFILLER_3_250 VGND VGND VPWR VPWR sky130_fd_sc_hd__fill_2
X_2052_ _2441_/Q _2052_/B _2052_/C VGND VGND VPWR VPWR _2052_/Y sky130_fd_sc_hd__nand3_1
X_2121_ _2121_/A _2121_/B _2121_/C VGND VGND VPWR VPWR _2122_/B sky130_fd_sc_hd__nand3_1
XTAP_TAPCELL_ROW_64_469 VGND VPWR sky130_fd_sc_hd__tapvpwrvgnd_1
X_1905_ _2534_/Q _2560_/Q _1971_/S VGND VGND VPWR VPWR _1905_/Y sky130_fd_sc_hd__mux2i_1
XTAP_TAPCELL_ROW_32_311 VGND VPWR sky130_fd_sc_hd__tapvpwrvgnd_1
X_1767_ _2463_/Q _2405_/Q VGND VGND VPWR VPWR _1768_/B sky130_fd_sc_hd__and2_0
X_1836_ _2511_/Q _2585_/Q _1902_/S VGND VGND VPWR VPWR _1836_/Y sky130_fd_sc_hd__mux2i_1
XPHY_EDGE_ROW_6_Right_6 VGND VGND VPWR VPWR sky130_fd_sc_hd__decap_3
X_1698_ _1672_/C _1697_/Y _2096_/A VGND VGND VPWR VPWR _2482_/D sky130_fd_sc_hd__a21oi_1
XFILLER_66_29 VGND VGND VPWR VPWR sky130_fd_sc_hd__fill_1
X_2319_ _2304_/Y _2306_/Y _2317_/X _2318_/Y VGND VGND VPWR VPWR _2321_/A sky130_fd_sc_hd__a211oi_1
XTAP_TAPCELL_ROW_55_425 VGND VPWR sky130_fd_sc_hd__tapvpwrvgnd_1
XFILLER_15_44 VGND VGND VPWR VPWR sky130_fd_sc_hd__decap_3
XFILLER_0_253 VGND VGND VPWR VPWR sky130_fd_sc_hd__decap_12
XFILLER_56_51 VGND VGND VPWR VPWR sky130_fd_sc_hd__decap_4
XPHY_EDGE_ROW_59_Right_59 VGND VGND VPWR VPWR sky130_fd_sc_hd__decap_3
XFILLER_31_113 VGND VGND VPWR VPWR sky130_fd_sc_hd__decap_6
XFILLER_16_187 VGND VGND VPWR VPWR sky130_fd_sc_hd__decap_8
X_1621_ _1627_/A _2455_/Q VGND VGND VPWR VPWR _1621_/Y sky130_fd_sc_hd__nand2_1
X_1552_ _2274_/A _2481_/Q _2480_/Q _1690_/A VGND VGND VPWR VPWR _1556_/A sky130_fd_sc_hd__nor4_1
XPHY_EDGE_ROW_68_Right_68 VGND VGND VPWR VPWR sky130_fd_sc_hd__decap_3
X_1483_ _1485_/A _1523_/B VGND VGND VPWR VPWR _1530_/A sky130_fd_sc_hd__nand2_1
X_2104_ _2102_/X _2103_/Y _2110_/B1 VGND VGND VPWR VPWR _2415_/D sky130_fd_sc_hd__a21oi_1
X_2035_ _1226_/Y _2034_/B _2034_/Y VGND VGND VPWR VPWR _2599_/D sky130_fd_sc_hd__a21oi_1
XTAP_TAPCELL_ROW_60_450 VGND VPWR sky130_fd_sc_hd__tapvpwrvgnd_1
X_1819_ _2506_/Q _2507_/Q _2633_/Q VGND VGND VPWR VPWR _1828_/B sky130_fd_sc_hd__and3_1
Xhold342 _2633_/Q VGND VGND VPWR VPWR _1825_/B sky130_fd_sc_hd__dlygate4sd3_1
Xhold320 _2583_/Q VGND VGND VPWR VPWR hold320/X sky130_fd_sc_hd__dlygate4sd3_1
Xhold375 _2604_/Q VGND VGND VPWR VPWR hold375/X sky130_fd_sc_hd__dlygate4sd3_1
Xhold364 _2069_/X VGND VGND VPWR VPWR _2401_/D sky130_fd_sc_hd__dlygate4sd3_1
Xhold353 _2420_/Q VGND VGND VPWR VPWR hold353/X sky130_fd_sc_hd__dlygate4sd3_1
Xhold331 _2573_/Q VGND VGND VPWR VPWR hold331/X sky130_fd_sc_hd__dlygate4sd3_1
XFILLER_13_113 VGND VGND VPWR VPWR sky130_fd_sc_hd__fill_1
XFILLER_44_282 VGND VGND VPWR VPWR sky130_fd_sc_hd__decap_6
X_2584_ _2606_/CLK _2584_/D fanout169/X VGND VGND VPWR VPWR _2584_/Q sky130_fd_sc_hd__dfrtp_1
Xfanout129 _2429_/Q VGND VGND VPWR VPWR _2198_/A sky130_fd_sc_hd__clkdlybuf4s50_1
X_1535_ _1532_/Y _1534_/Y _1533_/Y VGND VGND VPWR VPWR _1535_/Y sky130_fd_sc_hd__a21oi_1
Xfanout118 _2434_/Q VGND VGND VPWR VPWR _2316_/A sky130_fd_sc_hd__clkdlybuf4s50_1
X_1604_ _2609_/Q _1561_/B _1543_/Y VGND VGND VPWR VPWR _2375_/C sky130_fd_sc_hd__o21ai_0
Xfanout107 _2479_/Q VGND VGND VPWR VPWR _1690_/A sky130_fd_sc_hd__clkdlybuf4s50_1
X_1397_ _1383_/Y _1396_/A _1396_/B _1382_/Y VGND VGND VPWR VPWR wire36/A sky130_fd_sc_hd__o31ai_1
X_1466_ _2440_/Q _1466_/B VGND VGND VPWR VPWR _1467_/B sky130_fd_sc_hd__nor2_1
XFILLER_42_208 VGND VGND VPWR VPWR sky130_fd_sc_hd__decap_12
XFILLER_35_260 VGND VGND VPWR VPWR sky130_fd_sc_hd__fill_1
X_2018_ _2018_/A _2034_/B VGND VGND VPWR VPWR _2018_/Y sky130_fd_sc_hd__nor2_1
XFILLER_10_138 VGND VGND VPWR VPWR sky130_fd_sc_hd__fill_2
XFILLER_12_45 VGND VGND VPWR VPWR sky130_fd_sc_hd__fill_1
Xhold194 _2612_/Q VGND VGND VPWR VPWR _2613_/D sky130_fd_sc_hd__dlygate4sd3_1
XTAP_TAPCELL_ROW_5_175 VGND VPWR sky130_fd_sc_hd__tapvpwrvgnd_1
XTAP_TAPCELL_ROW_28_288 VGND VPWR sky130_fd_sc_hd__tapvpwrvgnd_1
X_1320_ _1340_/C _1320_/B VGND VGND VPWR VPWR _1321_/B sky130_fd_sc_hd__xor2_1
X_1251_ _2499_/Q VGND VGND VPWR VPWR _1812_/A sky130_fd_sc_hd__inv_1
XFILLER_32_241 VGND VGND VPWR VPWR sky130_fd_sc_hd__decap_6
XTAP_TAPCELL_ROW_19_244 VGND VPWR sky130_fd_sc_hd__tapvpwrvgnd_1
X_2498_ _2634_/CLK _2498_/D fanout182/X VGND VGND VPWR VPWR _2498_/Q sky130_fd_sc_hd__dfrtp_1
X_1518_ _2625_/Q _1523_/A _1515_/Y _1517_/Y VGND VGND VPWR VPWR _1518_/Y sky130_fd_sc_hd__o31ai_1
X_2567_ _2592_/CLK _2567_/D fanout148/X VGND VGND VPWR VPWR _2567_/Q sky130_fd_sc_hd__dfrtp_1
X_1449_ _2484_/Q _1416_/Y _1419_/Y _1448_/Y VGND VGND VPWR VPWR _1449_/Y sky130_fd_sc_hd__o22ai_1
XFILLER_23_77 VGND VGND VPWR VPWR sky130_fd_sc_hd__fill_1
XFILLER_3_3 VGND VGND VPWR VPWR sky130_fd_sc_hd__decap_8
XFILLER_2_134 VGND VGND VPWR VPWR sky130_fd_sc_hd__decap_6
XFILLER_0_15 VGND VGND VPWR VPWR sky130_fd_sc_hd__decap_12
XFILLER_9_57 VGND VGND VPWR VPWR sky130_fd_sc_hd__fill_2
X_1303_ _1303_/A _1393_/A VGND VGND VPWR VPWR _1303_/Y sky130_fd_sc_hd__nor2_1
X_2283_ _2283_/A _2283_/B VGND VGND VPWR VPWR _2283_/Y sky130_fd_sc_hd__nor2_1
X_2421_ _2606_/CLK _2421_/D _2429_/SET_B VGND VGND VPWR VPWR _2421_/Q sky130_fd_sc_hd__dfstp_2
XFILLER_36_3 VGND VGND VPWR VPWR sky130_fd_sc_hd__fill_2
X_2352_ _2351_/B _2350_/X _2351_/Y _1557_/A VGND VGND VPWR VPWR _2352_/Y sky130_fd_sc_hd__a211oi_1
X_1234_ _2450_/Q VGND VGND VPWR VPWR _1234_/Y sky130_fd_sc_hd__inv_1
XTAP_TAPCELL_ROW_47_383 VGND VPWR sky130_fd_sc_hd__tapvpwrvgnd_1
X_2619_ _2633_/CLK _2619_/D fanout187/A VGND VGND VPWR VPWR _2619_/Q sky130_fd_sc_hd__dfrtp_1
X_1998_ hold271/X _2403_/Q _1999_/S VGND VGND VPWR VPWR _1998_/X sky130_fd_sc_hd__mux2_1
XFILLER_70_188 VGND VGND VPWR VPWR sky130_fd_sc_hd__decap_8
XFILLER_38_108 VGND VGND VPWR VPWR sky130_fd_sc_hd__decap_6
XFILLER_61_177 VGND VGND VPWR VPWR sky130_fd_sc_hd__decap_4
XFILLER_61_166 VGND VGND VPWR VPWR sky130_fd_sc_hd__fill_2
X_1852_ _1852_/A _1945_/B VGND VGND VPWR VPWR _1852_/Y sky130_fd_sc_hd__nand2_1
X_1921_ _1921_/A _1948_/B VGND VGND VPWR VPWR _1921_/Y sky130_fd_sc_hd__nand2_1
X_1783_ _1783_/A _2050_/B VGND VGND VPWR VPWR _1783_/Y sky130_fd_sc_hd__nor2_1
Xfanout9 _2052_/Y VGND VGND VPWR VPWR _2076_/S sky130_fd_sc_hd__clkdlybuf4s50_1
X_2404_ _2634_/CLK _2404_/D load_slew177/X VGND VGND VPWR VPWR _2404_/Q sky130_fd_sc_hd__dfrtp_1
X_2266_ _2283_/B _2265_/Y _2173_/A VGND VGND VPWR VPWR _2266_/Y sky130_fd_sc_hd__a21oi_1
X_2335_ _2336_/A _2336_/B VGND VGND VPWR VPWR _2349_/A sky130_fd_sc_hd__nand2_1
X_2197_ _2198_/B _2474_/Q _2286_/S VGND VGND VPWR VPWR _2197_/X sky130_fd_sc_hd__mux2_1
XFILLER_52_133 VGND VGND VPWR VPWR sky130_fd_sc_hd__fill_1
X_1217_ _2082_/A VGND VGND VPWR VPWR _2101_/A sky130_fd_sc_hd__inv_1
XFILLER_45_20 VGND VGND VPWR VPWR sky130_fd_sc_hd__fill_2
XFILLER_28_141 VGND VGND VPWR VPWR sky130_fd_sc_hd__decap_6
XFILLER_45_42 VGND VGND VPWR VPWR sky130_fd_sc_hd__decap_6
XFILLER_43_166 VGND VGND VPWR VPWR sky130_fd_sc_hd__fill_2
XTAP_TAPCELL_ROW_41_356 VGND VPWR sky130_fd_sc_hd__tapvpwrvgnd_1
XFILLER_61_74 VGND VGND VPWR VPWR sky130_fd_sc_hd__fill_1
X_2120_ _2457_/Q _2399_/Q _2456_/Q _2398_/Q VGND VGND VPWR VPWR _2121_/C sky130_fd_sc_hd__nor4_1
XFILLER_66_247 VGND VGND VPWR VPWR sky130_fd_sc_hd__decap_4
X_2051_ _1247_/Y _2050_/B _2050_/Y VGND VGND VPWR VPWR _2607_/D sky130_fd_sc_hd__a21oi_1
XFILLER_19_163 VGND VGND VPWR VPWR sky130_fd_sc_hd__fill_1
X_1835_ _2504_/Q _2584_/Q _1831_/A _1969_/B hold251/X VGND VGND VPWR VPWR _1835_/X
+ sky130_fd_sc_hd__a32o_1
X_1904_ _1909_/B _1902_/Y _1903_/Y VGND VGND VPWR VPWR _1904_/Y sky130_fd_sc_hd__o21ai_0
X_1766_ _2463_/Q _2405_/Q VGND VGND VPWR VPWR _2119_/C sky130_fd_sc_hd__nor2_1
X_1697_ _2274_/A _1697_/B VGND VGND VPWR VPWR _1697_/Y sky130_fd_sc_hd__xnor2_1
XFILLER_57_225 VGND VGND VPWR VPWR sky130_fd_sc_hd__decap_8
X_2249_ _2229_/A _2229_/B _2235_/A _2234_/X _2248_/X VGND VGND VPWR VPWR _2249_/Y
+ sky130_fd_sc_hd__o311ai_1
X_2318_ _2318_/A _2318_/B VGND VGND VPWR VPWR _2318_/Y sky130_fd_sc_hd__nor2_1
XTAP_TAPCELL_ROW_55_426 VGND VPWR sky130_fd_sc_hd__tapvpwrvgnd_1
XFILLER_15_23 VGND VGND VPWR VPWR sky130_fd_sc_hd__fill_1
XFILLER_0_265 VGND VGND VPWR VPWR sky130_fd_sc_hd__decap_12
XFILLER_56_85 VGND VGND VPWR VPWR sky130_fd_sc_hd__decap_8
XFILLER_56_63 VGND VGND VPWR VPWR sky130_fd_sc_hd__decap_8
XFILLER_16_111 VGND VGND VPWR VPWR sky130_fd_sc_hd__fill_1
X_1482_ _2242_/A _1523_/A _1486_/D VGND VGND VPWR VPWR _1482_/Y sky130_fd_sc_hd__nor3_1
X_1551_ _2419_/Q _2420_/Q _2114_/B VGND VGND VPWR VPWR _1560_/B sky130_fd_sc_hd__nor3_1
X_1620_ _1231_/Y _1619_/Y _1624_/S VGND VGND VPWR VPWR _2453_/D sky130_fd_sc_hd__mux2i_1
XFILLER_39_236 VGND VGND VPWR VPWR sky130_fd_sc_hd__fill_1
XFILLER_39_225 VGND VGND VPWR VPWR sky130_fd_sc_hd__decap_4
X_2103_ _2414_/Q _2114_/C _2102_/D _2415_/Q VGND VGND VPWR VPWR _2103_/Y sky130_fd_sc_hd__o31ai_1
XFILLER_62_261 VGND VGND VPWR VPWR sky130_fd_sc_hd__fill_2
XTAP_TAPCELL_ROW_52_407 VGND VPWR sky130_fd_sc_hd__tapvpwrvgnd_1
X_2034_ _2034_/A _2034_/B VGND VGND VPWR VPWR _2034_/Y sky130_fd_sc_hd__nor2_1
X_1818_ _2510_/Q _2509_/Q VGND VGND VPWR VPWR _1833_/A sky130_fd_sc_hd__nand2_1
XTAP_TAPCELL_ROW_60_451 VGND VPWR sky130_fd_sc_hd__tapvpwrvgnd_1
Xhold310 _2587_/Q VGND VGND VPWR VPWR _2010_/A sky130_fd_sc_hd__dlygate4sd3_1
XFILLER_30_191 VGND VGND VPWR VPWR sky130_fd_sc_hd__fill_2
Xhold332 _2501_/Q VGND VGND VPWR VPWR _1806_/A sky130_fd_sc_hd__dlygate4sd3_1
Xhold321 _2493_/Q VGND VGND VPWR VPWR _1785_/A sky130_fd_sc_hd__dlygate4sd3_1
Xhold343 _2498_/Q VGND VGND VPWR VPWR hold343/X sky130_fd_sc_hd__dlygate4sd3_1
X_1749_ _1749_/A _1749_/B VGND VGND VPWR VPWR _1749_/Y sky130_fd_sc_hd__xnor2_1
Xhold365 _2386_/Q VGND VGND VPWR VPWR hold365/X sky130_fd_sc_hd__dlygate4sd3_1
Xhold376 _2524_/Q VGND VGND VPWR VPWR hold376/X sky130_fd_sc_hd__dlygate4sd3_1
Xhold354 _2632_/Q VGND VGND VPWR VPWR hold354/X sky130_fd_sc_hd__dlygate4sd3_1
XFILLER_53_272 VGND VGND VPWR VPWR sky130_fd_sc_hd__fill_1
XFILLER_53_261 VGND VGND VPWR VPWR sky130_fd_sc_hd__decap_6
XFILLER_13_158 VGND VGND VPWR VPWR sky130_fd_sc_hd__decap_8
XFILLER_13_169 VGND VGND VPWR VPWR sky130_fd_sc_hd__decap_4
XFILLER_67_51 VGND VGND VPWR VPWR sky130_fd_sc_hd__decap_4
XFILLER_66_3 VGND VGND VPWR VPWR sky130_fd_sc_hd__decap_8
XFILLER_8_195 VGND VGND VPWR VPWR sky130_fd_sc_hd__fill_1
X_2583_ _2607_/CLK _2583_/D fanout182/X VGND VGND VPWR VPWR _2583_/Q sky130_fd_sc_hd__dfrtp_1
X_1534_ _2630_/Q _1490_/X _1530_/Y _2629_/Q VGND VGND VPWR VPWR _1534_/Y sky130_fd_sc_hd__a22oi_1
Xfanout119 _2257_/A VGND VGND VPWR VPWR _1486_/A sky130_fd_sc_hd__clkdlybuf4s50_1
Xfanout108 _2438_/Q VGND VGND VPWR VPWR _2331_/B sky130_fd_sc_hd__clkdlybuf4s50_1
X_1465_ _2439_/Q _2609_/Q VGND VGND VPWR VPWR _1467_/A sky130_fd_sc_hd__nor2b_1
X_1603_ _1603_/A _1603_/B VGND VGND VPWR VPWR _2632_/D sky130_fd_sc_hd__nor2_1
X_1396_ _1396_/A _1396_/B VGND VGND VPWR VPWR _1423_/B sky130_fd_sc_hd__nor2_1
X_2017_ _1235_/Y _2032_/B _2016_/Y VGND VGND VPWR VPWR _2590_/D sky130_fd_sc_hd__a21oi_1
XFILLER_50_253 VGND VGND VPWR VPWR sky130_fd_sc_hd__fill_1
Xhold195 _2550_/Q VGND VGND VPWR VPWR _1951_/A sky130_fd_sc_hd__dlygate4sd3_1
XTAP_TAPCELL_ROW_5_176 VGND VPWR sky130_fd_sc_hd__tapvpwrvgnd_1
XFILLER_53_20 VGND VGND VPWR VPWR sky130_fd_sc_hd__decap_4
XFILLER_26_261 VGND VGND VPWR VPWR sky130_fd_sc_hd__decap_6
XTAP_TAPCELL_ROW_28_289 VGND VPWR sky130_fd_sc_hd__tapvpwrvgnd_1
X_1250_ _2498_/Q VGND VGND VPWR VPWR _1811_/A sky130_fd_sc_hd__inv_1
XTAP_TAPCELL_ROW_19_245 VGND VPWR sky130_fd_sc_hd__tapvpwrvgnd_1
XFILLER_17_261 VGND VGND VPWR VPWR sky130_fd_sc_hd__decap_8
X_2497_ _2634_/CLK _2497_/D load_slew175/X VGND VGND VPWR VPWR _2497_/Q sky130_fd_sc_hd__dfrtp_1
X_1517_ _1511_/Y _1513_/Y _1514_/Y _1516_/Y VGND VGND VPWR VPWR _1517_/Y sky130_fd_sc_hd__a31oi_1
X_1448_ _2289_/A _1419_/B _1444_/Y _1446_/Y _1447_/Y VGND VGND VPWR VPWR _1448_/Y
+ sky130_fd_sc_hd__a221oi_1
X_2566_ clkload2/A _2566_/D load_slew154/X VGND VGND VPWR VPWR _2566_/Q sky130_fd_sc_hd__dfrtp_1
XTAP_TAPCELL_ROW_2_157 VGND VPWR sky130_fd_sc_hd__tapvpwrvgnd_1
XFILLER_23_220 VGND VGND VPWR VPWR sky130_fd_sc_hd__fill_1
X_1379_ _1484_/A _2257_/A VGND VGND VPWR VPWR _1379_/Y sky130_fd_sc_hd__nand2_1
XFILLER_23_89 VGND VGND VPWR VPWR sky130_fd_sc_hd__decap_3
XFILLER_23_242 VGND VGND VPWR VPWR sky130_fd_sc_hd__decap_4
XFILLER_0_27 VGND VGND VPWR VPWR sky130_fd_sc_hd__fill_1
XFILLER_14_286 VGND VGND VPWR VPWR sky130_fd_sc_hd__decap_3
XTAP_TAPCELL_ROW_24_270 VGND VPWR sky130_fd_sc_hd__tapvpwrvgnd_1
Xfanout90 _2042_/B VGND VGND VPWR VPWR _2010_/B sky130_fd_sc_hd__clkdlybuf4s50_1
X_2420_ _2592_/CLK _2420_/D _2437_/SET_B VGND VGND VPWR VPWR _2420_/Q sky130_fd_sc_hd__dfstp_2
X_1302_ _2241_/B _2212_/B VGND VGND VPWR VPWR _1302_/Y sky130_fd_sc_hd__nand2_1
X_2282_ _2282_/A _2282_/B VGND VGND VPWR VPWR _2282_/X sky130_fd_sc_hd__xor2_1
X_2351_ _2351_/A _2351_/B VGND VGND VPWR VPWR _2351_/Y sky130_fd_sc_hd__nor2_1
X_1233_ _2451_/Q VGND VGND VPWR VPWR _1233_/Y sky130_fd_sc_hd__inv_1
XFILLER_29_3 VGND VGND VPWR VPWR sky130_fd_sc_hd__decap_6
XFILLER_64_197 VGND VGND VPWR VPWR sky130_fd_sc_hd__fill_1
XTAP_TAPCELL_ROW_47_384 VGND VPWR sky130_fd_sc_hd__tapvpwrvgnd_1
X_1997_ hold259/X _2402_/Q _2038_/B VGND VGND VPWR VPWR _1997_/X sky130_fd_sc_hd__mux2_1
X_2618_ _2633_/CLK _2618_/D fanout187/X VGND VGND VPWR VPWR _2618_/Q sky130_fd_sc_hd__dfrtp_1
X_2549_ clkload1/A _2549_/D load_slew152/X VGND VGND VPWR VPWR _2549_/Q sky130_fd_sc_hd__dfrtp_1
XFILLER_55_142 VGND VGND VPWR VPWR sky130_fd_sc_hd__fill_2
XFILLER_18_23 VGND VGND VPWR VPWR sky130_fd_sc_hd__decap_4
XTAP_TAPCELL_ROW_38_340 VGND VPWR sky130_fd_sc_hd__tapvpwrvgnd_1
XFILLER_11_223 VGND VGND VPWR VPWR sky130_fd_sc_hd__fill_1
XFILLER_11_245 VGND VGND VPWR VPWR sky130_fd_sc_hd__decap_4
XFILLER_59_85 VGND VGND VPWR VPWR sky130_fd_sc_hd__decap_8
XFILLER_59_52 VGND VGND VPWR VPWR sky130_fd_sc_hd__decap_4
XFILLER_46_197 VGND VGND VPWR VPWR sky130_fd_sc_hd__decap_4
XFILLER_46_186 VGND VGND VPWR VPWR sky130_fd_sc_hd__fill_2
Xload_slew66 _1956_/S VGND VGND VPWR VPWR _1884_/S sky130_fd_sc_hd__buf_4
Xload_slew11 _1624_/S VGND VGND VPWR VPWR _1628_/S sky130_fd_sc_hd__buf_4
XPHY_EDGE_ROW_28_Left_99 VGND VGND VPWR VPWR sky130_fd_sc_hd__decap_3
X_1851_ _2516_/Q hold380/X _1932_/S VGND VGND VPWR VPWR _1851_/Y sky130_fd_sc_hd__mux2i_1
X_1920_ _2539_/Q _2565_/Q _1947_/S VGND VGND VPWR VPWR _1920_/Y sky130_fd_sc_hd__mux2i_1
X_1782_ _1782_/A _1788_/C VGND VGND VPWR VPWR _1782_/Y sky130_fd_sc_hd__xnor2_1
X_2403_ clkload9/A _2403_/D load_slew177/X VGND VGND VPWR VPWR _2403_/Q sky130_fd_sc_hd__dfrtp_1
XFILLER_6_260 VGND VGND VPWR VPWR sky130_fd_sc_hd__fill_1
X_1216_ _2471_/Q VGND VGND VPWR VPWR _1216_/Y sky130_fd_sc_hd__inv_1
X_2196_ _2198_/B _2196_/B VGND VGND VPWR VPWR _2196_/Y sky130_fd_sc_hd__nor2_1
X_2265_ _2265_/A _2265_/B VGND VGND VPWR VPWR _2265_/Y sky130_fd_sc_hd__xnor2_1
X_2334_ _2316_/A _1202_/Y _2317_/X VGND VGND VPWR VPWR _2336_/B sky130_fd_sc_hd__a21o_1
XFILLER_20_68 VGND VGND VPWR VPWR sky130_fd_sc_hd__decap_8
XFILLER_28_197 VGND VGND VPWR VPWR sky130_fd_sc_hd__decap_12
XFILLER_43_156 VGND VGND VPWR VPWR sky130_fd_sc_hd__fill_2
XFILLER_6_26 VGND VGND VPWR VPWR sky130_fd_sc_hd__fill_2
X_2050_ _2050_/A _2050_/B VGND VGND VPWR VPWR _2050_/Y sky130_fd_sc_hd__nor2_1
XFILLER_20_7 VGND VGND VPWR VPWR sky130_fd_sc_hd__fill_1
XFILLER_34_134 VGND VGND VPWR VPWR sky130_fd_sc_hd__decap_6
X_1834_ _1833_/A _1965_/S _2633_/Q VGND VGND VPWR VPWR _1834_/Y sky130_fd_sc_hd__o21ai_0
X_1765_ _1999_/S _1763_/Y _1764_/Y VGND VGND VPWR VPWR _2489_/D sky130_fd_sc_hd__a21oi_1
X_1903_ _1903_/A _1909_/B VGND VGND VPWR VPWR _1903_/Y sky130_fd_sc_hd__nand2_1
X_1696_ _1672_/C _1695_/Y _2096_/A VGND VGND VPWR VPWR _2481_/D sky130_fd_sc_hd__a21oi_1
X_2179_ _2283_/B _2178_/X _2173_/A VGND VGND VPWR VPWR _2179_/Y sky130_fd_sc_hd__a21oi_1
X_2248_ _2248_/A _2248_/B VGND VGND VPWR VPWR _2248_/X sky130_fd_sc_hd__xor2_1
X_2317_ _2318_/A _2318_/B VGND VGND VPWR VPWR _2317_/X sky130_fd_sc_hd__and2_0
XFILLER_15_57 VGND VGND VPWR VPWR sky130_fd_sc_hd__fill_1
XFILLER_0_277 VGND VGND VPWR VPWR sky130_fd_sc_hd__decap_3
XFILLER_56_281 VGND VGND VPWR VPWR sky130_fd_sc_hd__fill_1
X_1481_ _2272_/B _1515_/B VGND VGND VPWR VPWR _1486_/D sky130_fd_sc_hd__nand2_1
X_1550_ _1550_/A _1550_/B VGND VGND VPWR VPWR _2114_/B sky130_fd_sc_hd__nand2_1
X_2102_ _2414_/Q _2415_/Q _2114_/C _2102_/D VGND VGND VPWR VPWR _2102_/X sky130_fd_sc_hd__or4_1
XFILLER_11_3 VGND VGND VPWR VPWR sky130_fd_sc_hd__decap_3
X_2033_ _1227_/Y _2032_/B _2032_/Y VGND VGND VPWR VPWR _2598_/D sky130_fd_sc_hd__a21oi_1
XFILLER_62_251 VGND VGND VPWR VPWR sky130_fd_sc_hd__fill_1
XTAP_TAPCELL_ROW_52_408 VGND VPWR sky130_fd_sc_hd__tapvpwrvgnd_1
XFILLER_22_137 VGND VGND VPWR VPWR sky130_fd_sc_hd__decap_3
XFILLER_22_159 VGND VGND VPWR VPWR sky130_fd_sc_hd__decap_3
X_1817_ _2634_/D pwm_out _1815_/Y _1816_/Y VGND VGND VPWR VPWR _2503_/D sky130_fd_sc_hd__o2bb2ai_1
Xhold344 _1799_/Y VGND VGND VPWR VPWR _1800_/B sky130_fd_sc_hd__dlygate4sd3_1
Xhold322 _2492_/Q VGND VGND VPWR VPWR _1783_/A sky130_fd_sc_hd__dlygate4sd3_1
X_1748_ _1755_/B _1755_/C VGND VGND VPWR VPWR _1749_/B sky130_fd_sc_hd__nand2_1
Xhold300 _2562_/Q VGND VGND VPWR VPWR hold300/X sky130_fd_sc_hd__dlygate4sd3_1
Xhold311 _2570_/Q VGND VGND VPWR VPWR hold311/X sky130_fd_sc_hd__dlygate4sd3_1
Xhold333 _2595_/Q VGND VGND VPWR VPWR _2026_/A sky130_fd_sc_hd__dlygate4sd3_1
XPHY_EDGE_ROW_15_Left_86 VGND VGND VPWR VPWR sky130_fd_sc_hd__decap_3
X_1679_ _1672_/C _1678_/Y _2136_/A VGND VGND VPWR VPWR _2474_/D sky130_fd_sc_hd__a21oi_1
Xhold355 _2385_/Q VGND VGND VPWR VPWR hold355/X sky130_fd_sc_hd__dlygate4sd3_1
Xhold366 _2387_/Q VGND VGND VPWR VPWR hold366/X sky130_fd_sc_hd__dlygate4sd3_1
Xhold377 _1875_/Y VGND VGND VPWR VPWR hold377/X sky130_fd_sc_hd__dlygate4sd3_1
XFILLER_53_284 VGND VGND VPWR VPWR sky130_fd_sc_hd__decap_4
XFILLER_67_41 VGND VGND VPWR VPWR sky130_fd_sc_hd__fill_1
XFILLER_44_251 VGND VGND VPWR VPWR sky130_fd_sc_hd__fill_1
X_2582_ _2607_/CLK _2582_/D fanout182/X VGND VGND VPWR VPWR _2582_/Q sky130_fd_sc_hd__dfrtp_1
XFILLER_59_3 VGND VGND VPWR VPWR sky130_fd_sc_hd__fill_1
XFILLER_8_141 VGND VGND VPWR VPWR sky130_fd_sc_hd__decap_3
X_1602_ _2631_/Q _1600_/B hold354/X VGND VGND VPWR VPWR _1603_/B sky130_fd_sc_hd__a21oi_1
X_1395_ _2255_/A _2230_/B VGND VGND VPWR VPWR _1396_/B sky130_fd_sc_hd__nor2_1
X_1533_ _2631_/Q _1488_/Y _1490_/X _2630_/Q VGND VGND VPWR VPWR _1533_/Y sky130_fd_sc_hd__o22ai_1
Xfanout109 _2438_/Q VGND VGND VPWR VPWR _1470_/B sky130_fd_sc_hd__clkdlybuf4s50_1
X_1464_ _2441_/Q _1464_/B _1464_/C VGND VGND VPWR VPWR _2614_/D sky130_fd_sc_hd__and3b_1
X_2016_ _2016_/A _2032_/B VGND VGND VPWR VPWR _2016_/Y sky130_fd_sc_hd__nor2_1
XFILLER_50_276 VGND VGND VPWR VPWR sky130_fd_sc_hd__decap_4
Xhold196 _2502_/Q VGND VGND VPWR VPWR _1807_/A sky130_fd_sc_hd__dlygate4sd3_1
XFILLER_26_240 VGND VGND VPWR VPWR sky130_fd_sc_hd__decap_4
XFILLER_41_276 VGND VGND VPWR VPWR sky130_fd_sc_hd__fill_1
XFILLER_5_111 VGND VGND VPWR VPWR sky130_fd_sc_hd__fill_1
XFILLER_68_118 VGND VGND VPWR VPWR sky130_fd_sc_hd__fill_2
XTAP_TAPCELL_ROW_19_246 VGND VPWR sky130_fd_sc_hd__tapvpwrvgnd_1
XFILLER_32_287 VGND VGND VPWR VPWR sky130_fd_sc_hd__fill_2
Xclkbuf_leaf_12_clk clkbuf_leaf_9_clk/A VGND VGND VPWR VPWR _2592_/CLK sky130_fd_sc_hd__clkbuf_16
X_2634_ _2634_/CLK _2634_/D load_slew175/X VGND VGND VPWR VPWR _2634_/Q sky130_fd_sc_hd__dfrtp_1
X_1516_ _2624_/Q _1516_/B _1516_/C VGND VGND VPWR VPWR _1516_/Y sky130_fd_sc_hd__nor3_1
X_2565_ clkload2/A _2565_/D fanout155/X VGND VGND VPWR VPWR _2565_/Q sky130_fd_sc_hd__dfrtp_1
X_2496_ _2634_/CLK _2496_/D load_slew175/X VGND VGND VPWR VPWR _2496_/Q sky130_fd_sc_hd__dfrtp_1
X_1447_ _2274_/A _1447_/B VGND VGND VPWR VPWR _1447_/Y sky130_fd_sc_hd__nor2_1
X_1378_ _2159_/A _2273_/A VGND VGND VPWR VPWR _1407_/A sky130_fd_sc_hd__nor2_1
XTAP_TAPCELL_ROW_2_158 VGND VPWR sky130_fd_sc_hd__tapvpwrvgnd_1
XFILLER_23_254 VGND VGND VPWR VPWR sky130_fd_sc_hd__fill_1
XPHY_EDGE_ROW_36_Left_107 VGND VGND VPWR VPWR sky130_fd_sc_hd__decap_3
XFILLER_23_287 VGND VGND VPWR VPWR sky130_fd_sc_hd__fill_2
XFILLER_58_195 VGND VGND VPWR VPWR sky130_fd_sc_hd__fill_1
XPHY_EDGE_ROW_45_Left_116 VGND VGND VPWR VPWR sky130_fd_sc_hd__decap_3
Xfanout80 _1458_/Y VGND VGND VPWR VPWR _1672_/B sky130_fd_sc_hd__clkdlybuf4s50_1
XPHY_EDGE_ROW_54_Left_125 VGND VGND VPWR VPWR sky130_fd_sc_hd__decap_3
Xfanout91 _2000_/S VGND VGND VPWR VPWR _2042_/B sky130_fd_sc_hd__clkdlybuf4s50_1
XFILLER_14_221 VGND VGND VPWR VPWR sky130_fd_sc_hd__fill_1
XFILLER_14_243 VGND VGND VPWR VPWR sky130_fd_sc_hd__decap_4
XTAP_TAPCELL_ROW_16_227 VGND VPWR sky130_fd_sc_hd__tapvpwrvgnd_1
XTAP_TAPCELL_ROW_24_271 VGND VPWR sky130_fd_sc_hd__tapvpwrvgnd_1
XPHY_EDGE_ROW_63_Left_134 VGND VGND VPWR VPWR sky130_fd_sc_hd__decap_3
X_1301_ _2242_/B _2176_/A VGND VGND VPWR VPWR _1393_/A sky130_fd_sc_hd__nor2_1
XFILLER_49_162 VGND VGND VPWR VPWR sky130_fd_sc_hd__fill_2
XFILLER_49_140 VGND VGND VPWR VPWR sky130_fd_sc_hd__fill_2
X_2281_ _2264_/A _2281_/A2 _2262_/Y _2282_/A _2263_/A VGND VGND VPWR VPWR _2295_/B
+ sky130_fd_sc_hd__a311oi_1
Xclkbuf_leaf_1_clk clkbuf_leaf_9_clk/A VGND VGND VPWR VPWR clkload2/A sky130_fd_sc_hd__clkbuf_16
X_2350_ _2350_/A _2350_/B VGND VGND VPWR VPWR _2350_/X sky130_fd_sc_hd__xor2_1
X_1232_ _2452_/Q VGND VGND VPWR VPWR _1232_/Y sky130_fd_sc_hd__inv_1
XTAP_TAPCELL_ROW_47_385 VGND VPWR sky130_fd_sc_hd__tapvpwrvgnd_1
X_1996_ hold288/X _2401_/Q _2038_/B VGND VGND VPWR VPWR _2576_/D sky130_fd_sc_hd__mux2_1
X_2617_ _2633_/CLK _2617_/D fanout187/X VGND VGND VPWR VPWR _2617_/Q sky130_fd_sc_hd__dfrtp_1
X_2548_ clkload1/A _2548_/D load_slew150/X VGND VGND VPWR VPWR _2548_/Q sky130_fd_sc_hd__dfrtp_1
XTAP_TAPCELL_ROW_38_341 VGND VPWR sky130_fd_sc_hd__tapvpwrvgnd_1
X_2479_ clkload3/A _2479_/D fanout159/A VGND VGND VPWR VPWR _2479_/Q sky130_fd_sc_hd__dfrtp_1
Xclkload0 clkload0/A VGND VGND VPWR VPWR clkload0/X sky130_fd_sc_hd__clkbuf_16
XTAP_TAPCELL_ROW_21_252 VGND VPWR sky130_fd_sc_hd__tapvpwrvgnd_1
XPHY_EDGE_ROW_3_Left_74 VGND VGND VPWR VPWR sky130_fd_sc_hd__decap_3
XFILLER_61_113 VGND VGND VPWR VPWR sky130_fd_sc_hd__decap_6
X_1781_ _1777_/A _1774_/Y _2119_/D VGND VGND VPWR VPWR _1788_/C sky130_fd_sc_hd__a21oi_1
X_1850_ _1945_/B _1848_/Y _1849_/Y VGND VGND VPWR VPWR _2516_/D sky130_fd_sc_hd__o21ai_0
X_2402_ clkload9/A _2402_/D load_slew168/X VGND VGND VPWR VPWR _2402_/Q sky130_fd_sc_hd__dfrtp_1
X_2333_ _2333_/A _2333_/B VGND VGND VPWR VPWR _2336_/A sky130_fd_sc_hd__xnor2_1
XFILLER_69_279 VGND VGND VPWR VPWR sky130_fd_sc_hd__fill_1
X_1215_ _2473_/Q VGND VGND VPWR VPWR _1215_/Y sky130_fd_sc_hd__inv_1
X_2195_ fanout3/X _2184_/Y _2194_/Y _2196_/B _1389_/B VGND VGND VPWR VPWR _2425_/D
+ sky130_fd_sc_hd__o32a_1
X_2264_ _2264_/A _2264_/B VGND VGND VPWR VPWR _2265_/B sky130_fd_sc_hd__nand2_1
XTAP_TAPCELL_ROW_35_322 VGND VPWR sky130_fd_sc_hd__tapvpwrvgnd_1
X_1979_ _1979_/A _2010_/B VGND VGND VPWR VPWR _2130_/A sky130_fd_sc_hd__nor2b_1
XTAP_TAPCELL_ROW_66_480 VGND VPWR sky130_fd_sc_hd__tapvpwrvgnd_1
XFILLER_28_132 VGND VGND VPWR VPWR sky130_fd_sc_hd__fill_2
XFILLER_28_187 VGND VGND VPWR VPWR sky130_fd_sc_hd__fill_2
XFILLER_13_7 VGND VGND VPWR VPWR sky130_fd_sc_hd__fill_1
X_1902_ _2533_/Q _2607_/Q _1902_/S VGND VGND VPWR VPWR _1902_/Y sky130_fd_sc_hd__mux2i_1
XFILLER_34_157 VGND VGND VPWR VPWR sky130_fd_sc_hd__fill_2
X_1833_ _1833_/A _1833_/B VGND VGND VPWR VPWR _1833_/Y sky130_fd_sc_hd__nor2_1
X_1764_ _1764_/A _1999_/S VGND VGND VPWR VPWR _1764_/Y sky130_fd_sc_hd__nor2_1
X_2316_ _2316_/A _2316_/B VGND VGND VPWR VPWR _2318_/B sky130_fd_sc_hd__xnor2_1
X_1695_ _2259_/A _1695_/B VGND VGND VPWR VPWR _1695_/Y sky130_fd_sc_hd__xnor2_1
X_2178_ _2191_/A _2191_/B _2191_/C VGND VGND VPWR VPWR _2178_/X sky130_fd_sc_hd__xor3_1
X_2247_ _2248_/A _2248_/B VGND VGND VPWR VPWR _2264_/A sky130_fd_sc_hd__nand2_1
XFILLER_63_208 VGND VGND VPWR VPWR sky130_fd_sc_hd__decap_3
XFILLER_16_146 VGND VGND VPWR VPWR sky130_fd_sc_hd__fill_2
XFILLER_16_157 VGND VGND VPWR VPWR sky130_fd_sc_hd__fill_1
XPHY_EDGE_ROW_19_Right_19 VGND VGND VPWR VPWR sky130_fd_sc_hd__decap_3
X_1480_ _2257_/B _1512_/B VGND VGND VPWR VPWR _1515_/B sky130_fd_sc_hd__nor2_1
XPHY_EDGE_ROW_28_Right_28 VGND VGND VPWR VPWR sky130_fd_sc_hd__decap_3
XPHY_EDGE_ROW_37_Right_37 VGND VGND VPWR VPWR sky130_fd_sc_hd__decap_3
X_2101_ _2101_/A _2114_/C wire16/X VGND VGND VPWR VPWR _2101_/Y sky130_fd_sc_hd__nor3_1
X_2032_ _2032_/A _2032_/B VGND VGND VPWR VPWR _2032_/Y sky130_fd_sc_hd__nor2_1
XTAP_TAPCELL_ROW_52_409 VGND VPWR sky130_fd_sc_hd__tapvpwrvgnd_1
Xhold345 _2506_/Q VGND VGND VPWR VPWR _1825_/A sky130_fd_sc_hd__dlygate4sd3_1
X_1678_ _2474_/Q _1678_/B VGND VGND VPWR VPWR _1678_/Y sky130_fd_sc_hd__xnor2_1
X_1816_ _1254_/Y _2494_/Q _2634_/Q VGND VGND VPWR VPWR _1816_/Y sky130_fd_sc_hd__o21ai_0
Xhold356 _2634_/Q VGND VGND VPWR VPWR _1222_/A sky130_fd_sc_hd__dlygate4sd3_1
Xhold323 _2579_/Q VGND VGND VPWR VPWR hold323/X sky130_fd_sc_hd__dlygate4sd3_1
XPHY_EDGE_ROW_46_Right_46 VGND VGND VPWR VPWR sky130_fd_sc_hd__decap_3
Xhold301 _1982_/X VGND VGND VPWR VPWR _2562_/D sky130_fd_sc_hd__dlygate4sd3_1
Xhold378 _2588_/Q VGND VGND VPWR VPWR hold378/X sky130_fd_sc_hd__dlygate4sd3_1
Xhold334 _2599_/Q VGND VGND VPWR VPWR _2034_/A sky130_fd_sc_hd__dlygate4sd3_1
Xhold367 _2412_/Q VGND VGND VPWR VPWR hold367/X sky130_fd_sc_hd__dlygate4sd3_1
Xhold312 _1990_/X VGND VGND VPWR VPWR _2570_/D sky130_fd_sc_hd__dlygate4sd3_1
X_1747_ _1734_/Y _1741_/Y _1744_/Y _1746_/Y VGND VGND VPWR VPWR _1755_/C sky130_fd_sc_hd__a31o_1
XPHY_EDGE_ROW_55_Right_55 VGND VGND VPWR VPWR sky130_fd_sc_hd__decap_3
XFILLER_26_79 VGND VGND VPWR VPWR sky130_fd_sc_hd__decap_4
XPHY_EDGE_ROW_64_Right_64 VGND VGND VPWR VPWR sky130_fd_sc_hd__decap_3
XFILLER_21_160 VGND VGND VPWR VPWR sky130_fd_sc_hd__decap_3
XFILLER_67_64 VGND VGND VPWR VPWR sky130_fd_sc_hd__fill_1
XFILLER_36_208 VGND VGND VPWR VPWR sky130_fd_sc_hd__fill_1
X_2581_ _2607_/CLK _2581_/D _2494_/SET_B VGND VGND VPWR VPWR _2581_/Q sky130_fd_sc_hd__dfrtp_1
X_1532_ _1526_/Y _1529_/X _1531_/X VGND VGND VPWR VPWR _1532_/Y sky130_fd_sc_hd__o21ai_0
XFILLER_8_197 VGND VGND VPWR VPWR sky130_fd_sc_hd__decap_8
X_1601_ _1603_/A _1601_/B VGND VGND VPWR VPWR _2631_/D sky130_fd_sc_hd__nor2_1
X_1394_ _2257_/B _2230_/B _1302_/Y _1427_/A _1393_/B VGND VGND VPWR VPWR _1396_/A
+ sky130_fd_sc_hd__a221oi_1
X_1463_ _1651_/B _1657_/C _1561_/B VGND VGND VPWR VPWR _1464_/C sky130_fd_sc_hd__nor3_1
X_2015_ _1236_/Y _2032_/B _2014_/Y VGND VGND VPWR VPWR _2589_/D sky130_fd_sc_hd__a21oi_1
XFILLER_12_37 VGND VGND VPWR VPWR sky130_fd_sc_hd__decap_8
Xhold197 _2549_/Q VGND VGND VPWR VPWR _1948_/A sky130_fd_sc_hd__dlygate4sd3_1
XFILLER_37_67 VGND VGND VPWR VPWR sky130_fd_sc_hd__fill_2
XFILLER_37_23 VGND VGND VPWR VPWR sky130_fd_sc_hd__decap_3
XFILLER_41_222 VGND VGND VPWR VPWR sky130_fd_sc_hd__fill_2
X_2633_ _2633_/CLK _2633_/D fanout187/X VGND VGND VPWR VPWR _2633_/Q sky130_fd_sc_hd__dfrtp_1
X_2495_ _2634_/CLK _2495_/D load_slew175/X VGND VGND VPWR VPWR _2495_/Q sky130_fd_sc_hd__dfrtp_1
XFILLER_59_119 VGND VGND VPWR VPWR sky130_fd_sc_hd__fill_1
X_1515_ _2230_/A _1515_/B VGND VGND VPWR VPWR _1515_/Y sky130_fd_sc_hd__xnor2_1
X_2564_ clkload2/A _2564_/D fanout155/X VGND VGND VPWR VPWR _2564_/Q sky130_fd_sc_hd__dfrtp_1
XTAP_TAPCELL_ROW_2_159 VGND VPWR sky130_fd_sc_hd__tapvpwrvgnd_1
X_1446_ _2481_/Q _1443_/X _1447_/B _2274_/A VGND VGND VPWR VPWR _1446_/Y sky130_fd_sc_hd__a22oi_1
X_1377_ _1484_/A _2158_/B VGND VGND VPWR VPWR _1408_/B sky130_fd_sc_hd__nand2_1
XFILLER_58_141 VGND VGND VPWR VPWR sky130_fd_sc_hd__decap_12
XTAP_TAPCELL_ROW_16_228 VGND VPWR sky130_fd_sc_hd__tapvpwrvgnd_1
Xfanout92 _2000_/S VGND VGND VPWR VPWR _1999_/S sky130_fd_sc_hd__clkdlybuf4s50_1
XFILLER_14_233 VGND VGND VPWR VPWR sky130_fd_sc_hd__fill_2
X_1300_ _2257_/B _2242_/B VGND VGND VPWR VPWR _1305_/A sky130_fd_sc_hd__xnor2_1
X_2280_ _2264_/A _2281_/A2 _2262_/Y _2263_/A VGND VGND VPWR VPWR _2282_/B sky130_fd_sc_hd__a31oi_1
X_1231_ _2453_/Q VGND VGND VPWR VPWR _1231_/Y sky130_fd_sc_hd__inv_1
XTAP_TAPCELL_ROW_47_386 VGND VPWR sky130_fd_sc_hd__tapvpwrvgnd_1
X_2616_ _2616_/CLK input2/X fanout188/X VGND VGND VPWR VPWR _2616_/Q sky130_fd_sc_hd__dfrtp_1
X_1995_ hold292/X _2400_/Q _2032_/B VGND VGND VPWR VPWR _2575_/D sky130_fd_sc_hd__mux2_1
XTAP_TAPCELL_ROW_30_297 VGND VPWR sky130_fd_sc_hd__tapvpwrvgnd_1
XFILLER_9_281 VGND VGND VPWR VPWR sky130_fd_sc_hd__decap_8
XFILLER_20_247 VGND VGND VPWR VPWR sky130_fd_sc_hd__fill_1
X_1429_ _1429_/A _1429_/B VGND VGND VPWR VPWR _1434_/B sky130_fd_sc_hd__xnor2_1
X_2478_ _2616_/CLK _2478_/D fanout185/X VGND VGND VPWR VPWR _2478_/Q sky130_fd_sc_hd__dfrtp_1
X_2547_ clkload7/A _2547_/D load_slew144/X VGND VGND VPWR VPWR _2547_/Q sky130_fd_sc_hd__dfrtp_1
XFILLER_55_177 VGND VGND VPWR VPWR sky130_fd_sc_hd__decap_3
XFILLER_50_23 VGND VGND VPWR VPWR sky130_fd_sc_hd__fill_2
XFILLER_11_225 VGND VGND VPWR VPWR sky130_fd_sc_hd__decap_3
XTAP_TAPCELL_ROW_21_253 VGND VPWR sky130_fd_sc_hd__tapvpwrvgnd_1
Xclkload1 clkload1/A VGND VGND VPWR VPWR clkload1/X sky130_fd_sc_hd__clkbuf_1
XFILLER_1_3 VGND VGND VPWR VPWR sky130_fd_sc_hd__decap_12
Xload_slew13 _1638_/S VGND VGND VPWR VPWR _2384_/S sky130_fd_sc_hd__buf_4
Xload_slew68 _1965_/S VGND VGND VPWR VPWR _1902_/S sky130_fd_sc_hd__buf_4
XFILLER_61_103 VGND VGND VPWR VPWR sky130_fd_sc_hd__fill_2
XFILLER_46_144 VGND VGND VPWR VPWR sky130_fd_sc_hd__fill_2
XTAP_TAPCELL_ROW_44_367 VGND VPWR sky130_fd_sc_hd__tapvpwrvgnd_1
X_1780_ _2465_/Q _2407_/Q VGND VGND VPWR VPWR _1782_/A sky130_fd_sc_hd__xor2_1
X_2401_ clkload1/A _2401_/D load_slew168/X VGND VGND VPWR VPWR _2401_/Q sky130_fd_sc_hd__dfrtp_1
XFILLER_34_3 VGND VGND VPWR VPWR sky130_fd_sc_hd__decap_12
X_2332_ _2332_/A _2333_/B VGND VGND VPWR VPWR _2346_/C sky130_fd_sc_hd__nand2_1
X_2194_ _2224_/A2 _2192_/X _2193_/Y VGND VGND VPWR VPWR _2194_/Y sky130_fd_sc_hd__a21oi_1
X_1214_ _2475_/Q VGND VGND VPWR VPWR _1680_/A sky130_fd_sc_hd__inv_1
X_2263_ _2263_/A _2263_/B VGND VGND VPWR VPWR _2265_/A sky130_fd_sc_hd__nor2_1
XTAP_TAPCELL_ROW_35_323 VGND VPWR sky130_fd_sc_hd__tapvpwrvgnd_1
X_1978_ _1978_/A _2010_/B VGND VGND VPWR VPWR _1980_/A sky130_fd_sc_hd__nor2_1
XFILLER_20_26 VGND VGND VPWR VPWR sky130_fd_sc_hd__fill_2
XTAP_TAPCELL_ROW_58_437 VGND VPWR sky130_fd_sc_hd__tapvpwrvgnd_1
XFILLER_29_57 VGND VGND VPWR VPWR sky130_fd_sc_hd__decap_4
XTAP_TAPCELL_ROW_66_481 VGND VPWR sky130_fd_sc_hd__tapvpwrvgnd_1
XFILLER_43_147 VGND VGND VPWR VPWR sky130_fd_sc_hd__fill_1
XFILLER_51_191 VGND VGND VPWR VPWR sky130_fd_sc_hd__decap_3
XFILLER_3_232 VGND VGND VPWR VPWR sky130_fd_sc_hd__fill_1
XFILLER_19_111 VGND VGND VPWR VPWR sky130_fd_sc_hd__fill_1
X_1832_ _2506_/Q _2508_/Q _2507_/Q i2s_ws VGND VGND VPWR VPWR _1833_/B sky130_fd_sc_hd__nand4_1
X_1901_ _1969_/B _1899_/Y _1900_/Y VGND VGND VPWR VPWR _1901_/Y sky130_fd_sc_hd__o21ai_0
XFILLER_42_180 VGND VGND VPWR VPWR sky130_fd_sc_hd__decap_4
X_1763_ _1763_/A _1763_/B VGND VGND VPWR VPWR _1763_/Y sky130_fd_sc_hd__xnor2_1
X_1694_ _1672_/C _1693_/Y _1543_/B VGND VGND VPWR VPWR _2480_/D sky130_fd_sc_hd__a21oi_1
X_2246_ _2230_/A _1303_/A _2231_/Y VGND VGND VPWR VPWR _2248_/B sky130_fd_sc_hd__o21ai_0
X_2315_ _2149_/B _2359_/S _2314_/Y VGND VGND VPWR VPWR _2315_/Y sky130_fd_sc_hd__a21oi_1
XTAP_TAPCELL_ROW_63_462 VGND VPWR sky130_fd_sc_hd__tapvpwrvgnd_1
X_2177_ _2475_/Q _2177_/B VGND VGND VPWR VPWR _2191_/C sky130_fd_sc_hd__xnor2_1
XFILLER_25_169 VGND VGND VPWR VPWR sky130_fd_sc_hd__decap_12
XFILLER_56_261 VGND VGND VPWR VPWR sky130_fd_sc_hd__decap_12
X_2100_ _2082_/A _2414_/Q _2114_/C _2099_/Y VGND VGND VPWR VPWR _2414_/D sky130_fd_sc_hd__o31ai_1
XFILLER_62_253 VGND VGND VPWR VPWR sky130_fd_sc_hd__decap_8
X_2031_ _1228_/Y _2032_/B _2030_/Y VGND VGND VPWR VPWR _2597_/D sky130_fd_sc_hd__a21oi_1
X_1815_ _1254_/Y _2494_/Q _1814_/X VGND VGND VPWR VPWR _1815_/Y sky130_fd_sc_hd__a21oi_1
XFILLER_30_183 VGND VGND VPWR VPWR sky130_fd_sc_hd__decap_8
XFILLER_30_150 VGND VGND VPWR VPWR sky130_fd_sc_hd__decap_8
X_1677_ _1672_/C _1676_/X _2136_/A VGND VGND VPWR VPWR _2473_/D sky130_fd_sc_hd__a21oi_1
Xhold357 _2508_/Q VGND VGND VPWR VPWR _1828_/A sky130_fd_sc_hd__dlygate4sd3_1
Xhold324 _2509_/Q VGND VGND VPWR VPWR _1829_/A sky130_fd_sc_hd__dlygate4sd3_1
Xhold302 _2586_/Q VGND VGND VPWR VPWR _2008_/A sky130_fd_sc_hd__dlygate4sd3_1
Xhold379 _2385_/Q VGND VGND VPWR VPWR _1979_/A sky130_fd_sc_hd__dlygate4sd3_1
Xhold335 _2421_/Q VGND VGND VPWR VPWR _1223_/A sky130_fd_sc_hd__dlygate4sd3_1
Xhold313 _2600_/Q VGND VGND VPWR VPWR _2036_/A sky130_fd_sc_hd__dlygate4sd3_1
Xhold368 _2390_/Q VGND VGND VPWR VPWR hold368/X sky130_fd_sc_hd__dlygate4sd3_1
XFILLER_7_60 VGND VGND VPWR VPWR sky130_fd_sc_hd__fill_2
Xhold346 _2441_/Q VGND VGND VPWR VPWR _2373_/A sky130_fd_sc_hd__dlygate4sd3_1
X_1746_ _2121_/A _1740_/A _1741_/B _1734_/Y _1745_/Y VGND VGND VPWR VPWR _1746_/Y
+ sky130_fd_sc_hd__o221ai_1
X_2229_ _2229_/A _2229_/B VGND VGND VPWR VPWR _2236_/A sky130_fd_sc_hd__or2_0
XFILLER_38_261 VGND VGND VPWR VPWR sky130_fd_sc_hd__decap_3
XFILLER_3_18 VGND VGND VPWR VPWR sky130_fd_sc_hd__fill_1
XTAP_TAPCELL_ROW_8_187 VGND VPWR sky130_fd_sc_hd__tapvpwrvgnd_1
XFILLER_67_98 VGND VGND VPWR VPWR sky130_fd_sc_hd__fill_2
XFILLER_44_264 VGND VGND VPWR VPWR sky130_fd_sc_hd__decap_6
XFILLER_44_253 VGND VGND VPWR VPWR sky130_fd_sc_hd__fill_1
XFILLER_8_121 VGND VGND VPWR VPWR sky130_fd_sc_hd__fill_2
X_2580_ _2634_/CLK _2580_/D load_slew177/X VGND VGND VPWR VPWR _2580_/Q sky130_fd_sc_hd__dfrtp_1
X_1531_ _2628_/Q _1528_/X _1530_/Y _2629_/Q VGND VGND VPWR VPWR _1531_/X sky130_fd_sc_hd__o22a_1
X_1600_ _2631_/Q _1600_/B VGND VGND VPWR VPWR _1601_/B sky130_fd_sc_hd__xnor2_1
X_1462_ _1561_/B _2375_/B VGND VGND VPWR VPWR _1657_/D sky130_fd_sc_hd__nor2_1
X_1393_ _1393_/A _1393_/B VGND VGND VPWR VPWR _1427_/B sky130_fd_sc_hd__nor2_1
X_2014_ _2014_/A _2032_/B VGND VGND VPWR VPWR _2014_/Y sky130_fd_sc_hd__nor2_1
X_1729_ _2452_/Q _2394_/Q _2451_/Q _2393_/Q VGND VGND VPWR VPWR _1729_/Y sky130_fd_sc_hd__a22oi_1
Xhold198 _2469_/Q VGND VGND VPWR VPWR _1657_/B sky130_fd_sc_hd__dlygate4sd3_1
XFILLER_37_57 VGND VGND VPWR VPWR sky130_fd_sc_hd__fill_2
XFILLER_37_46 VGND VGND VPWR VPWR sky130_fd_sc_hd__fill_2
XFILLER_5_146 VGND VGND VPWR VPWR sky130_fd_sc_hd__decap_4
XFILLER_5_113 VGND VGND VPWR VPWR sky130_fd_sc_hd__decap_12
XFILLER_64_3 VGND VGND VPWR VPWR sky130_fd_sc_hd__decap_4
X_2632_ clkload5/A _2632_/D load_slew162/X VGND VGND VPWR VPWR _2632_/Q sky130_fd_sc_hd__dfrtp_1
X_2494_ _2607_/CLK _2494_/D _2494_/SET_B VGND VGND VPWR VPWR _2494_/Q sky130_fd_sc_hd__dfstp_2
X_1514_ _1514_/A1 _1491_/Y _2623_/Q VGND VGND VPWR VPWR _1514_/Y sky130_fd_sc_hd__o21ai_0
X_2563_ clkload2/A _2563_/D fanout155/X VGND VGND VPWR VPWR _2563_/Q sky130_fd_sc_hd__dfrtp_1
X_1445_ _1445_/A wire32/X VGND VGND VPWR VPWR _1447_/B sky130_fd_sc_hd__xnor2_1
X_1376_ _2159_/A _1470_/B VGND VGND VPWR VPWR _1412_/A sky130_fd_sc_hd__nor2_1
XFILLER_58_153 VGND VGND VPWR VPWR sky130_fd_sc_hd__decap_6
XFILLER_58_197 VGND VGND VPWR VPWR sky130_fd_sc_hd__fill_2
XTAP_TAPCELL_ROW_16_229 VGND VPWR sky130_fd_sc_hd__tapvpwrvgnd_1
Xfanout82 _1458_/Y VGND VGND VPWR VPWR _2254_/B2 sky130_fd_sc_hd__clkdlybuf4s50_1
Xfanout71 _1833_/Y VGND VGND VPWR VPWR _1947_/S sky130_fd_sc_hd__clkdlybuf4s50_1
Xfanout93 _2000_/S VGND VGND VPWR VPWR _2050_/B sky130_fd_sc_hd__clkdlybuf4s50_1
XFILLER_64_134 VGND VGND VPWR VPWR sky130_fd_sc_hd__fill_1
XFILLER_1_193 VGND VGND VPWR VPWR sky130_fd_sc_hd__decap_8
X_1230_ _2454_/Q VGND VGND VPWR VPWR _1230_/Y sky130_fd_sc_hd__inv_1
XFILLER_20_204 VGND VGND VPWR VPWR sky130_fd_sc_hd__decap_12
X_1994_ hold281/X _2399_/Q _2032_/B VGND VGND VPWR VPWR _2574_/D sky130_fd_sc_hd__mux2_1
X_2615_ _2633_/CLK _2615_/D fanout187/X VGND VGND VPWR VPWR block_start sky130_fd_sc_hd__dfrtp_1
XTAP_TAPCELL_ROW_30_298 VGND VPWR sky130_fd_sc_hd__tapvpwrvgnd_1
X_1428_ _1428_/A _1428_/B VGND VGND VPWR VPWR _1435_/B sky130_fd_sc_hd__xnor2_1
X_2477_ _2616_/CLK _2477_/D fanout183/A VGND VGND VPWR VPWR _2477_/Q sky130_fd_sc_hd__dfrtp_1
X_2546_ clkload6/A _2546_/D load_slew144/X VGND VGND VPWR VPWR _2546_/Q sky130_fd_sc_hd__dfrtp_1
XFILLER_70_104 VGND VGND VPWR VPWR sky130_fd_sc_hd__decap_4
XFILLER_34_25 VGND VGND VPWR VPWR sky130_fd_sc_hd__decap_3
XFILLER_18_37 VGND VGND VPWR VPWR sky130_fd_sc_hd__decap_3
X_1359_ _1484_/A _2158_/B VGND VGND VPWR VPWR _1470_/C sky130_fd_sc_hd__or2_0
XTAP_TAPCELL_ROW_21_254 VGND VPWR sky130_fd_sc_hd__tapvpwrvgnd_1
Xclkload2 clkload2/A VGND VGND VPWR VPWR clkload2/Y sky130_fd_sc_hd__clkinv_2
XFILLER_59_66 VGND VGND VPWR VPWR sky130_fd_sc_hd__decap_4
XTAP_TAPCELL_ROW_44_368 VGND VPWR sky130_fd_sc_hd__tapvpwrvgnd_1
XTAP_TAPCELL_ROW_12_210 VGND VPWR sky130_fd_sc_hd__tapvpwrvgnd_1
X_2400_ clkload1/A _2400_/D load_slew152/X VGND VGND VPWR VPWR _2400_/Q sky130_fd_sc_hd__dfrtp_1
X_1213_ _2476_/Q VGND VGND VPWR VPWR _2201_/C sky130_fd_sc_hd__inv_1
X_2262_ _2263_/B VGND VGND VPWR VPWR _2262_/Y sky130_fd_sc_hd__inv_1
X_2331_ _2331_/A _2331_/B VGND VGND VPWR VPWR _2333_/B sky130_fd_sc_hd__xnor2_1
XFILLER_27_3 VGND VGND VPWR VPWR sky130_fd_sc_hd__decap_3
X_2193_ _2185_/B _2224_/A2 _2360_/A VGND VGND VPWR VPWR _2193_/Y sky130_fd_sc_hd__o21ai_0
XFILLER_52_148 VGND VGND VPWR VPWR sky130_fd_sc_hd__fill_1
XFILLER_52_104 VGND VGND VPWR VPWR sky130_fd_sc_hd__fill_1
XTAP_TAPCELL_ROW_35_324 VGND VPWR sky130_fd_sc_hd__tapvpwrvgnd_1
X_1977_ i2s_bclk _1977_/B VGND VGND VPWR VPWR _2559_/D sky130_fd_sc_hd__xor2_1
X_2529_ clkload8/A _2529_/D fanout165/X VGND VGND VPWR VPWR _2529_/Q sky130_fd_sc_hd__dfrtp_1
XTAP_TAPCELL_ROW_58_438 VGND VPWR sky130_fd_sc_hd__tapvpwrvgnd_1
XFILLER_6_29 VGND VGND VPWR VPWR sky130_fd_sc_hd__fill_2
XFILLER_66_229 VGND VGND VPWR VPWR sky130_fd_sc_hd__fill_1
XFILLER_19_167 VGND VGND VPWR VPWR sky130_fd_sc_hd__fill_1
X_1831_ _1831_/A _1831_/B VGND VGND VPWR VPWR _2510_/D sky130_fd_sc_hd__nor2_1
X_1900_ _1900_/A _1969_/B VGND VGND VPWR VPWR _1900_/Y sky130_fd_sc_hd__nand2_1
X_1762_ _2462_/Q _2404_/Q VGND VGND VPWR VPWR _1763_/B sky130_fd_sc_hd__xnor2_1
X_1693_ _1695_/B _1693_/B VGND VGND VPWR VPWR _1693_/Y sky130_fd_sc_hd__nand2_1
XPHY_EDGE_ROW_69_Left_140 VGND VGND VPWR VPWR sky130_fd_sc_hd__decap_3
X_2176_ _2176_/A _2187_/B VGND VGND VPWR VPWR _2177_/B sky130_fd_sc_hd__xnor2_1
XFILLER_57_218 VGND VGND VPWR VPWR sky130_fd_sc_hd__decap_6
X_2245_ _2245_/A _2260_/B VGND VGND VPWR VPWR _2248_/A sky130_fd_sc_hd__nor2_1
X_2314_ _2316_/A _2359_/S _1557_/A VGND VGND VPWR VPWR _2314_/Y sky130_fd_sc_hd__o21ai_0
XFILLER_65_273 VGND VGND VPWR VPWR sky130_fd_sc_hd__decap_6
XFILLER_65_251 VGND VGND VPWR VPWR sky130_fd_sc_hd__decap_8
XTAP_TAPCELL_ROW_63_463 VGND VPWR sky130_fd_sc_hd__tapvpwrvgnd_1
XFILLER_31_15 VGND VGND VPWR VPWR sky130_fd_sc_hd__fill_2
XFILLER_0_225 VGND VGND VPWR VPWR sky130_fd_sc_hd__decap_12
XPHY_EDGE_ROW_1_Right_1 VGND VGND VPWR VPWR sky130_fd_sc_hd__decap_3
XFILLER_56_273 VGND VGND VPWR VPWR sky130_fd_sc_hd__decap_8
XFILLER_56_251 VGND VGND VPWR VPWR sky130_fd_sc_hd__fill_1
XFILLER_48_229 VGND VGND VPWR VPWR sky130_fd_sc_hd__fill_2
XFILLER_21_81 VGND VGND VPWR VPWR sky130_fd_sc_hd__decap_12
XFILLER_39_207 VGND VGND VPWR VPWR sky130_fd_sc_hd__decap_6
X_2030_ _2030_/A _2032_/B VGND VGND VPWR VPWR _2030_/Y sky130_fd_sc_hd__nor2_1
XFILLER_62_287 VGND VGND VPWR VPWR sky130_fd_sc_hd__fill_2
X_1814_ _1814_/A _2493_/Q _1814_/C VGND VGND VPWR VPWR _1814_/X sky130_fd_sc_hd__maj3_1
X_1745_ _2459_/Q _2401_/Q VGND VGND VPWR VPWR _1745_/Y sky130_fd_sc_hd__nand2_1
X_1676_ _1678_/B _1676_/B VGND VGND VPWR VPWR _1676_/X sky130_fd_sc_hd__or2_0
Xhold358 _2617_/Q VGND VGND VPWR VPWR _1567_/A sky130_fd_sc_hd__dlygate4sd3_1
Xhold347 _2496_/Q VGND VGND VPWR VPWR hold347/X sky130_fd_sc_hd__dlygate4sd3_1
Xhold325 _2489_/Q VGND VGND VPWR VPWR _1764_/A sky130_fd_sc_hd__dlygate4sd3_1
Xhold336 _2495_/Q VGND VGND VPWR VPWR _1793_/A sky130_fd_sc_hd__dlygate4sd3_1
Xhold303 _2510_/Q VGND VGND VPWR VPWR hold303/X sky130_fd_sc_hd__dlygate4sd3_1
Xhold314 _2588_/Q VGND VGND VPWR VPWR _2012_/A sky130_fd_sc_hd__dlygate4sd3_1
Xhold369 _2395_/Q VGND VGND VPWR VPWR hold369/X sky130_fd_sc_hd__dlygate4sd3_1
X_2228_ _2201_/C _2255_/B _2227_/Y VGND VGND VPWR VPWR _2228_/Y sky130_fd_sc_hd__a21oi_1
X_2159_ _2159_/A _2307_/A VGND VGND VPWR VPWR _2159_/Y sky130_fd_sc_hd__nand2_1
XFILLER_67_55 VGND VGND VPWR VPWR sky130_fd_sc_hd__fill_1
XFILLER_67_33 VGND VGND VPWR VPWR sky130_fd_sc_hd__decap_8
XTAP_TAPCELL_ROW_8_188 VGND VPWR sky130_fd_sc_hd__tapvpwrvgnd_1
XFILLER_8_155 VGND VGND VPWR VPWR sky130_fd_sc_hd__fill_1
XFILLER_8_177 VGND VGND VPWR VPWR sky130_fd_sc_hd__fill_2
XFILLER_12_195 VGND VGND VPWR VPWR sky130_fd_sc_hd__fill_1
X_1392_ _2241_/B _2212_/B VGND VGND VPWR VPWR _1393_/B sky130_fd_sc_hd__nor2_1
X_1530_ _1530_/A _1530_/B VGND VGND VPWR VPWR _1530_/Y sky130_fd_sc_hd__xnor2_1
X_1461_ _1374_/A _1374_/B _2442_/Q VGND VGND VPWR VPWR _2375_/B sky130_fd_sc_hd__a21oi_1
X_2013_ _1237_/Y _2038_/B _2012_/Y VGND VGND VPWR VPWR _2588_/D sky130_fd_sc_hd__a21oi_1
XFILLER_50_246 VGND VGND VPWR VPWR sky130_fd_sc_hd__decap_6
XFILLER_35_265 VGND VGND VPWR VPWR sky130_fd_sc_hd__decap_8
XFILLER_35_254 VGND VGND VPWR VPWR sky130_fd_sc_hd__decap_6
X_1728_ _2450_/Q _2392_/Q VGND VGND VPWR VPWR _2126_/B sky130_fd_sc_hd__nor2_1
X_1659_ _2473_/Q _2472_/Q _2471_/Q VGND VGND VPWR VPWR _1678_/B sky130_fd_sc_hd__and3_1
Xhold199 _2546_/Q VGND VGND VPWR VPWR _1939_/A sky130_fd_sc_hd__dlygate4sd3_1
XFILLER_53_24 VGND VGND VPWR VPWR sky130_fd_sc_hd__fill_1
XFILLER_41_213 VGND VGND VPWR VPWR sky130_fd_sc_hd__fill_1
XFILLER_26_287 VGND VGND VPWR VPWR sky130_fd_sc_hd__fill_2
XFILLER_53_57 VGND VGND VPWR VPWR sky130_fd_sc_hd__decap_3
XFILLER_32_268 VGND VGND VPWR VPWR sky130_fd_sc_hd__decap_4
XTAP_TAPCELL_ROW_27_282 VGND VPWR sky130_fd_sc_hd__tapvpwrvgnd_1
XFILLER_27_91 VGND VGND VPWR VPWR sky130_fd_sc_hd__fill_2
X_2562_ clkload8/A _2562_/D load_slew172/X VGND VGND VPWR VPWR _2562_/Q sky130_fd_sc_hd__dfrtp_1
X_2631_ clkload5/A _2631_/D load_slew162/X VGND VGND VPWR VPWR _2631_/Q sky130_fd_sc_hd__dfrtp_1
X_2493_ _2607_/CLK _2493_/D _2494_/SET_B VGND VGND VPWR VPWR _2493_/Q sky130_fd_sc_hd__dfrtp_1
Xclkbuf_leaf_4_clk clkload0/A VGND VGND VPWR VPWR _2634_/CLK sky130_fd_sc_hd__clkbuf_16
X_1513_ _1514_/A1 _1516_/C _2624_/Q VGND VGND VPWR VPWR _1513_/Y sky130_fd_sc_hd__o21ai_0
X_1375_ _2442_/Q _2167_/A VGND VGND VPWR VPWR _1375_/Y sky130_fd_sc_hd__nand2_1
X_1444_ _2480_/Q _1421_/X _1443_/X _2481_/Q _1441_/Y VGND VGND VPWR VPWR _1444_/Y
+ sky130_fd_sc_hd__o221ai_1
XFILLER_23_235 VGND VGND VPWR VPWR sky130_fd_sc_hd__decap_4
XFILLER_23_246 VGND VGND VPWR VPWR sky130_fd_sc_hd__fill_1
XFILLER_23_279 VGND VGND VPWR VPWR sky130_fd_sc_hd__fill_1
Xfanout94 _2000_/S VGND VGND VPWR VPWR _2003_/S sky130_fd_sc_hd__clkdlybuf4s50_1
Xfanout50 _1909_/B VGND VGND VPWR VPWR _1951_/B sky130_fd_sc_hd__clkdlybuf4s50_1
Xfanout61 _1932_/S VGND VGND VPWR VPWR _1926_/S sky130_fd_sc_hd__clkdlybuf4s50_1
XPHY_EDGE_ROW_32_Left_103 VGND VGND VPWR VPWR sky130_fd_sc_hd__decap_3
XPHY_EDGE_ROW_41_Left_112 VGND VGND VPWR VPWR sky130_fd_sc_hd__decap_3
XFILLER_9_261 VGND VGND VPWR VPWR sky130_fd_sc_hd__decap_3
X_1993_ hold331/X _2398_/Q _2020_/B VGND VGND VPWR VPWR _2573_/D sky130_fd_sc_hd__mux2_1
XFILLER_20_216 VGND VGND VPWR VPWR sky130_fd_sc_hd__decap_12
XTAP_TAPCELL_ROW_30_299 VGND VPWR sky130_fd_sc_hd__tapvpwrvgnd_1
X_2545_ clkload6/A _2545_/D load_slew142/X VGND VGND VPWR VPWR _2545_/Q sky130_fd_sc_hd__dfrtp_1
X_2614_ clkload5/A _2614_/D fanout155/X VGND VGND VPWR VPWR _2614_/Q sky130_fd_sc_hd__dfrtp_1
X_2476_ _2616_/CLK _2476_/D fanout191/X VGND VGND VPWR VPWR _2476_/Q sky130_fd_sc_hd__dfrtp_1
XPHY_EDGE_ROW_50_Left_121 VGND VGND VPWR VPWR sky130_fd_sc_hd__decap_3
X_1427_ _1427_/A _1427_/B VGND VGND VPWR VPWR _1436_/B sky130_fd_sc_hd__xnor2_1
XFILLER_18_27 VGND VGND VPWR VPWR sky130_fd_sc_hd__fill_1
X_1358_ _1484_/A _2158_/B VGND VGND VPWR VPWR _1358_/Y sky130_fd_sc_hd__nor2_1
XFILLER_70_149 VGND VGND VPWR VPWR sky130_fd_sc_hd__decap_3
X_1289_ _1289_/A _1289_/B _1289_/C VGND VGND VPWR VPWR _1289_/X sky130_fd_sc_hd__and3_1
XFILLER_34_15 VGND VGND VPWR VPWR sky130_fd_sc_hd__fill_1
Xclkload3 clkload3/A VGND VGND VPWR VPWR clkload3/Y sky130_fd_sc_hd__inv_8
XFILLER_11_249 VGND VGND VPWR VPWR sky130_fd_sc_hd__fill_1
XTAP_TAPCELL_ROW_21_255 VGND VPWR sky130_fd_sc_hd__tapvpwrvgnd_1
XTAP_TAPCELL_ROW_44_369 VGND VPWR sky130_fd_sc_hd__tapvpwrvgnd_1
XTAP_TAPCELL_ROW_12_211 VGND VPWR sky130_fd_sc_hd__tapvpwrvgnd_1
X_2192_ _2192_/A _2192_/B VGND VGND VPWR VPWR _2192_/X sky130_fd_sc_hd__xor2_1
X_1212_ _2477_/Q VGND VGND VPWR VPWR _2200_/A sky130_fd_sc_hd__inv_1
X_2261_ _2260_/A _2260_/B _2260_/C VGND VGND VPWR VPWR _2263_/B sky130_fd_sc_hd__o21a_1
X_2330_ _2331_/A _2330_/B VGND VGND VPWR VPWR _2346_/B sky130_fd_sc_hd__nand2_1
XTAP_TAPCELL_ROW_35_325 VGND VPWR sky130_fd_sc_hd__tapvpwrvgnd_1
X_1976_ _1975_/B _1974_/Y _1975_/Y VGND VGND VPWR VPWR _2558_/D sky130_fd_sc_hd__o21ai_0
XFILLER_60_171 VGND VGND VPWR VPWR sky130_fd_sc_hd__fill_1
X_2528_ clkload8/A _2528_/D load_slew166/X VGND VGND VPWR VPWR _2528_/Q sky130_fd_sc_hd__dfrtp_1
XTAP_TAPCELL_ROW_58_439 VGND VPWR sky130_fd_sc_hd__tapvpwrvgnd_1
X_2459_ clkload9/A _2459_/D load_slew168/X VGND VGND VPWR VPWR _2459_/Q sky130_fd_sc_hd__dfrtp_1
XFILLER_61_57 VGND VGND VPWR VPWR sky130_fd_sc_hd__decap_4
XPHY_EDGE_ROW_7_Left_78 VGND VGND VPWR VPWR sky130_fd_sc_hd__decap_3
XFILLER_3_278 VGND VGND VPWR VPWR sky130_fd_sc_hd__fill_2
XFILLER_19_113 VGND VGND VPWR VPWR sky130_fd_sc_hd__decap_6
XFILLER_19_157 VGND VGND VPWR VPWR sky130_fd_sc_hd__fill_2
X_1830_ hold373/X _2508_/Q _1828_/B hold303/X VGND VGND VPWR VPWR _1831_/B sky130_fd_sc_hd__a31oi_1
X_1761_ _2462_/Q _2404_/Q VGND VGND VPWR VPWR _2119_/B sky130_fd_sc_hd__nor2_1
XTAP_TAPCELL_ROW_40_350 VGND VPWR sky130_fd_sc_hd__tapvpwrvgnd_1
X_2313_ fanout3/X _2302_/Y _2312_/Y _2327_/B _2305_/B VGND VGND VPWR VPWR _2433_/D
+ sky130_fd_sc_hd__o32a_1
X_1692_ _1692_/A _1692_/B VGND VGND VPWR VPWR _1693_/B sky130_fd_sc_hd__nand2_1
X_2175_ _1431_/B _2472_/Q _2255_/B VGND VGND VPWR VPWR _2175_/X sky130_fd_sc_hd__mux2_1
XFILLER_57_208 VGND VGND VPWR VPWR sky130_fd_sc_hd__decap_3
X_2244_ _2480_/Q _2244_/B VGND VGND VPWR VPWR _2260_/B sky130_fd_sc_hd__and2_0
XTAP_TAPCELL_ROW_63_464 VGND VPWR sky130_fd_sc_hd__tapvpwrvgnd_1
X_1959_ _2552_/Q _2578_/Q _1965_/S VGND VGND VPWR VPWR _1959_/Y sky130_fd_sc_hd__mux2i_1
XFILLER_0_237 VGND VGND VPWR VPWR sky130_fd_sc_hd__decap_12
XTAP_TAPCELL_ROW_54_420 VGND VPWR sky130_fd_sc_hd__tapvpwrvgnd_1
XFILLER_31_119 VGND VGND VPWR VPWR sky130_fd_sc_hd__fill_1
XFILLER_47_285 VGND VGND VPWR VPWR sky130_fd_sc_hd__decap_4
Xclkbuf_0_clk clk VGND VGND VPWR VPWR clkbuf_0_clk/X sky130_fd_sc_hd__clkbuf_16
XFILLER_15_160 VGND VGND VPWR VPWR sky130_fd_sc_hd__decap_8
X_1813_ _1813_/A _2492_/Q _1813_/C VGND VGND VPWR VPWR _1814_/C sky130_fd_sc_hd__maj3_1
Xhold326 _2490_/Q VGND VGND VPWR VPWR _1771_/A sky130_fd_sc_hd__dlygate4sd3_1
XFILLER_30_141 VGND VGND VPWR VPWR sky130_fd_sc_hd__fill_1
Xhold315 _2589_/Q VGND VGND VPWR VPWR _2014_/A sky130_fd_sc_hd__dlygate4sd3_1
Xhold304 _2596_/Q VGND VGND VPWR VPWR _2028_/A sky130_fd_sc_hd__dlygate4sd3_1
X_1744_ _1730_/X _1743_/X _1742_/Y VGND VGND VPWR VPWR _1744_/Y sky130_fd_sc_hd__o21ai_0
X_1675_ _2472_/Q _2471_/Q _2473_/Q VGND VGND VPWR VPWR _1676_/B sky130_fd_sc_hd__a21oi_1
Xhold348 _1795_/Y VGND VGND VPWR VPWR _1796_/B sky130_fd_sc_hd__dlygate4sd3_1
Xhold337 _1793_/X VGND VGND VPWR VPWR _2495_/D sky130_fd_sc_hd__dlygate4sd3_1
Xhold359 _2402_/Q VGND VGND VPWR VPWR hold359/X sky130_fd_sc_hd__dlygate4sd3_1
XPHY_EDGE_ROW_15_Right_15 VGND VGND VPWR VPWR sky130_fd_sc_hd__decap_3
XFILLER_53_200 VGND VGND VPWR VPWR sky130_fd_sc_hd__decap_4
X_2227_ _2201_/A _2255_/B _2173_/A VGND VGND VPWR VPWR _2227_/Y sky130_fd_sc_hd__o21ai_0
X_2089_ hold367/X _2078_/Y _2080_/Y _2088_/Y VGND VGND VPWR VPWR _2412_/D sky130_fd_sc_hd__o2bb2ai_1
X_2158_ _2485_/Q _2158_/B VGND VGND VPWR VPWR _2158_/Y sky130_fd_sc_hd__nand2b_1
XPHY_EDGE_ROW_24_Right_24 VGND VGND VPWR VPWR sky130_fd_sc_hd__decap_3
XFILLER_53_288 VGND VGND VPWR VPWR sky130_fd_sc_hd__fill_1
XFILLER_21_174 VGND VGND VPWR VPWR sky130_fd_sc_hd__decap_8
XPHY_EDGE_ROW_33_Right_33 VGND VGND VPWR VPWR sky130_fd_sc_hd__decap_3
XTAP_TAPCELL_ROW_8_189 VGND VPWR sky130_fd_sc_hd__tapvpwrvgnd_1
XFILLER_44_288 VGND VGND VPWR VPWR sky130_fd_sc_hd__fill_1
XFILLER_44_211 VGND VGND VPWR VPWR sky130_fd_sc_hd__decap_3
XPHY_EDGE_ROW_42_Right_42 VGND VGND VPWR VPWR sky130_fd_sc_hd__decap_3
XPHY_EDGE_ROW_51_Right_51 VGND VGND VPWR VPWR sky130_fd_sc_hd__decap_3
XFILLER_8_189 VGND VGND VPWR VPWR sky130_fd_sc_hd__decap_6
XFILLER_12_141 VGND VGND VPWR VPWR sky130_fd_sc_hd__decap_3
X_1391_ _2201_/A _1391_/B _1428_/A VGND VGND VPWR VPWR _1427_/A sky130_fd_sc_hd__maj3_1
X_1460_ _2379_/A _1543_/B VGND VGND VPWR VPWR _1561_/B sky130_fd_sc_hd__nand2_1
XPHY_EDGE_ROW_60_Right_60 VGND VGND VPWR VPWR sky130_fd_sc_hd__decap_3
X_2012_ _2012_/A _2038_/B VGND VGND VPWR VPWR _2012_/Y sky130_fd_sc_hd__nor2_1
XFILLER_50_258 VGND VGND VPWR VPWR sky130_fd_sc_hd__fill_2
XFILLER_50_203 VGND VGND VPWR VPWR sky130_fd_sc_hd__decap_4
XFILLER_35_288 VGND VGND VPWR VPWR sky130_fd_sc_hd__fill_1
X_1727_ _2451_/Q _2393_/Q VGND VGND VPWR VPWR _2126_/A sky130_fd_sc_hd__nor2_1
X_1658_ _1255_/Y _1464_/C _1657_/Y VGND VGND VPWR VPWR _2470_/D sky130_fd_sc_hd__o21ai_0
X_1589_ _2627_/Q _2626_/Q _1589_/C VGND VGND VPWR VPWR _1594_/C sky130_fd_sc_hd__and3_1
XFILLER_41_247 VGND VGND VPWR VPWR sky130_fd_sc_hd__decap_4
XFILLER_41_225 VGND VGND VPWR VPWR sky130_fd_sc_hd__decap_8
XTAP_TAPCELL_ROW_4_170 VGND VPWR sky130_fd_sc_hd__tapvpwrvgnd_1
XTAP_TAPCELL_ROW_27_283 VGND VPWR sky130_fd_sc_hd__tapvpwrvgnd_1
X_2492_ _2607_/CLK _2492_/D _2494_/SET_B VGND VGND VPWR VPWR _2492_/Q sky130_fd_sc_hd__dfrtp_1
X_1512_ _1512_/A _1512_/B VGND VGND VPWR VPWR _1516_/C sky130_fd_sc_hd__xnor2_1
X_2561_ _2606_/CLK _2561_/D load_slew172/X VGND VGND VPWR VPWR _2561_/Q sky130_fd_sc_hd__dfrtp_1
X_2630_ clkload5/A _2630_/D load_slew162/X VGND VGND VPWR VPWR _2630_/Q sky130_fd_sc_hd__dfrtp_1
XFILLER_67_166 VGND VGND VPWR VPWR sky130_fd_sc_hd__fill_2
X_1374_ _1374_/A _1374_/B VGND VGND VPWR VPWR _2168_/A sky130_fd_sc_hd__nand2_1
X_1443_ _1443_/A _1443_/B VGND VGND VPWR VPWR _1443_/X sky130_fd_sc_hd__xor2_1
XFILLER_58_133 VGND VGND VPWR VPWR sky130_fd_sc_hd__decap_4
XFILLER_58_111 VGND VGND VPWR VPWR sky130_fd_sc_hd__fill_2
Xfanout51 _1909_/B VGND VGND VPWR VPWR _1954_/B sky130_fd_sc_hd__clkdlybuf4s50_1
XFILLER_14_225 VGND VGND VPWR VPWR sky130_fd_sc_hd__decap_8
Xfanout84 _1256_/Y VGND VGND VPWR VPWR _2360_/A sky130_fd_sc_hd__clkdlybuf4s50_1
Xfanout95 _2614_/Q VGND VGND VPWR VPWR _2000_/S sky130_fd_sc_hd__clkdlybuf4s50_1
XFILLER_38_91 VGND VGND VPWR VPWR sky130_fd_sc_hd__fill_1
Xclkload10 _2634_/CLK VGND VGND VPWR VPWR clkload10/X sky130_fd_sc_hd__clkbuf_1
X_1992_ hold278/X _2397_/Q _2020_/B VGND VGND VPWR VPWR _1992_/X sky130_fd_sc_hd__mux2_1
XFILLER_20_228 VGND VGND VPWR VPWR sky130_fd_sc_hd__decap_4
X_2613_ _2616_/CLK _2613_/D fanout190/X VGND VGND VPWR VPWR _2613_/Q sky130_fd_sc_hd__dfrtp_1
X_2475_ _2616_/CLK _2475_/D fanout190/X VGND VGND VPWR VPWR _2475_/Q sky130_fd_sc_hd__dfrtp_1
X_2544_ clkload6/A _2544_/D load_slew142/X VGND VGND VPWR VPWR _2544_/Q sky130_fd_sc_hd__dfrtp_1
X_1288_ _2212_/B _2137_/A _1472_/A _1269_/Y _1266_/Y VGND VGND VPWR VPWR _1289_/C
+ sky130_fd_sc_hd__o221ai_1
X_1426_ _1426_/A _1426_/B VGND VGND VPWR VPWR _1437_/B sky130_fd_sc_hd__xnor2_1
X_1357_ _1357_/A _1357_/B VGND VGND VPWR VPWR _1357_/Y sky130_fd_sc_hd__nor2_1
XFILLER_55_169 VGND VGND VPWR VPWR sky130_fd_sc_hd__decap_3
Xclkload4 clkload4/A VGND VGND VPWR VPWR clkload4/Y sky130_fd_sc_hd__inv_4
XTAP_TAPCELL_ROW_21_256 VGND VPWR sky130_fd_sc_hd__tapvpwrvgnd_1
XTAP_TAPCELL_ROW_69_492 VGND VPWR sky130_fd_sc_hd__tapvpwrvgnd_1
XFILLER_6_265 VGND VGND VPWR VPWR sky130_fd_sc_hd__decap_12
X_2191_ _2191_/A _2191_/B _2191_/C VGND VGND VPWR VPWR _2192_/B sky130_fd_sc_hd__maj3_1
X_1211_ _2478_/Q VGND VGND VPWR VPWR _1688_/A sky130_fd_sc_hd__inv_1
X_2260_ _2260_/A _2260_/B _2260_/C VGND VGND VPWR VPWR _2263_/A sky130_fd_sc_hd__nor3_1
XFILLER_37_169 VGND VGND VPWR VPWR sky130_fd_sc_hd__decap_12
XTAP_TAPCELL_ROW_35_326 VGND VPWR sky130_fd_sc_hd__tapvpwrvgnd_1
XPHY_EDGE_ROW_23_Left_94 VGND VGND VPWR VPWR sky130_fd_sc_hd__decap_3
X_1975_ _1975_/A _1975_/B VGND VGND VPWR VPWR _1975_/Y sky130_fd_sc_hd__nand2_1
X_2527_ clkload8/A _2527_/D load_slew168/X VGND VGND VPWR VPWR _2527_/Q sky130_fd_sc_hd__dfrtp_1
X_2458_ clkload2/A _2458_/D fanout151/X VGND VGND VPWR VPWR _2458_/Q sky130_fd_sc_hd__dfrtp_1
X_1409_ _1358_/Y _1407_/A _1407_/B _1408_/B VGND VGND VPWR VPWR _1415_/A sky130_fd_sc_hd__o31a_1
X_2389_ clkload2/A _2389_/D fanout153/X VGND VGND VPWR VPWR _2389_/Q sky130_fd_sc_hd__dfrtp_1
XFILLER_61_47 VGND VGND VPWR VPWR sky130_fd_sc_hd__fill_1
XTAP_TAPCELL_ROW_32_307 VGND VPWR sky130_fd_sc_hd__tapvpwrvgnd_1
XFILLER_19_169 VGND VGND VPWR VPWR sky130_fd_sc_hd__fill_2
X_1760_ _2462_/Q _2404_/Q VGND VGND VPWR VPWR _1760_/Y sky130_fd_sc_hd__nand2_1
XTAP_TAPCELL_ROW_40_351 VGND VPWR sky130_fd_sc_hd__tapvpwrvgnd_1
X_1691_ _1672_/C _1690_/Y _1543_/B VGND VGND VPWR VPWR _2479_/D sky130_fd_sc_hd__a21oi_1
X_2312_ _2351_/B _2311_/Y _2303_/Y _1557_/A VGND VGND VPWR VPWR _2312_/Y sky130_fd_sc_hd__a211oi_1
X_2174_ fanout3/X _2166_/Y _2173_/Y _2196_/B _2171_/A VGND VGND VPWR VPWR _2423_/D
+ sky130_fd_sc_hd__o32a_1
X_2243_ _2480_/Q _2244_/B VGND VGND VPWR VPWR _2245_/A sky130_fd_sc_hd__nor2_1
XTAP_TAPCELL_ROW_63_465 VGND VPWR sky130_fd_sc_hd__tapvpwrvgnd_1
X_1958_ _1966_/B _1956_/Y _1957_/Y VGND VGND VPWR VPWR _1958_/Y sky130_fd_sc_hd__o21ai_0
X_1889_ _1954_/B _1887_/Y _1888_/Y VGND VGND VPWR VPWR _1889_/Y sky130_fd_sc_hd__o21ai_0
XFILLER_0_249 VGND VGND VPWR VPWR sky130_fd_sc_hd__decap_3
XFILLER_56_253 VGND VGND VPWR VPWR sky130_fd_sc_hd__fill_1
XTAP_TAPCELL_ROW_54_421 VGND VPWR sky130_fd_sc_hd__tapvpwrvgnd_1
XFILLER_24_183 VGND VGND VPWR VPWR sky130_fd_sc_hd__decap_12
XFILLER_47_231 VGND VGND VPWR VPWR sky130_fd_sc_hd__decap_8
XFILLER_62_245 VGND VGND VPWR VPWR sky130_fd_sc_hd__decap_6
XFILLER_15_183 VGND VGND VPWR VPWR sky130_fd_sc_hd__decap_12
X_1674_ _1672_/C _1673_/Y _2136_/A VGND VGND VPWR VPWR _2472_/D sky130_fd_sc_hd__a21oi_1
Xhold349 _2494_/Q VGND VGND VPWR VPWR _1259_/A sky130_fd_sc_hd__dlygate4sd3_1
Xhold327 _2491_/Q VGND VGND VPWR VPWR _1778_/A sky130_fd_sc_hd__dlygate4sd3_1
X_1812_ _1812_/A _2491_/Q _1812_/C VGND VGND VPWR VPWR _1813_/C sky130_fd_sc_hd__maj3_1
Xhold316 _2606_/Q VGND VGND VPWR VPWR _2048_/A sky130_fd_sc_hd__dlygate4sd3_1
XFILLER_30_197 VGND VGND VPWR VPWR sky130_fd_sc_hd__decap_6
XFILLER_30_175 VGND VGND VPWR VPWR sky130_fd_sc_hd__decap_3
Xhold338 _2523_/Q VGND VGND VPWR VPWR _1870_/A sky130_fd_sc_hd__dlygate4sd3_1
X_1743_ _1743_/A _2126_/C _2126_/D _2125_/B VGND VGND VPWR VPWR _1743_/X sky130_fd_sc_hd__or4_1
Xhold305 _2598_/Q VGND VGND VPWR VPWR _2032_/A sky130_fd_sc_hd__dlygate4sd3_1
X_2226_ fanout3/X _2225_/Y _2212_/B _2254_/B2 VGND VGND VPWR VPWR _2427_/D sky130_fd_sc_hd__a2bb2oi_1
XFILLER_53_278 VGND VGND VPWR VPWR sky130_fd_sc_hd__fill_2
XTAP_TAPCELL_ROW_51_402 VGND VPWR sky130_fd_sc_hd__tapvpwrvgnd_1
XFILLER_38_253 VGND VGND VPWR VPWR sky130_fd_sc_hd__decap_8
X_2088_ _2088_/A _2090_/B VGND VGND VPWR VPWR _2088_/Y sky130_fd_sc_hd__nand2_1
XFILLER_13_109 VGND VGND VPWR VPWR sky130_fd_sc_hd__decap_3
X_2157_ _2159_/A _2307_/A _2289_/A _2331_/A VGND VGND VPWR VPWR _2157_/Y sky130_fd_sc_hd__o22ai_1
XFILLER_26_39 VGND VGND VPWR VPWR sky130_fd_sc_hd__decap_12
XPHY_EDGE_ROW_10_Left_81 VGND VGND VPWR VPWR sky130_fd_sc_hd__decap_3
XFILLER_44_245 VGND VGND VPWR VPWR sky130_fd_sc_hd__decap_6
XFILLER_32_82 VGND VGND VPWR VPWR sky130_fd_sc_hd__fill_2
XFILLER_12_197 VGND VGND VPWR VPWR sky130_fd_sc_hd__decap_4
X_1390_ _2201_/A _1391_/B VGND VGND VPWR VPWR _1428_/B sky130_fd_sc_hd__xor2_1
X_2011_ _1238_/Y _2010_/B _2010_/Y VGND VGND VPWR VPWR _2587_/D sky130_fd_sc_hd__a21oi_1
X_1588_ _1603_/A _1588_/B VGND VGND VPWR VPWR _2626_/D sky130_fd_sc_hd__nor2_1
X_1657_ _2468_/Q _1657_/B _1657_/C _1657_/D VGND VGND VPWR VPWR _1657_/Y sky130_fd_sc_hd__nand4_1
X_1726_ _1723_/X _2124_/C _1725_/X VGND VGND VPWR VPWR _1726_/Y sky130_fd_sc_hd__a21oi_1
X_2209_ _2365_/B1 _2197_/X _2254_/B2 VGND VGND VPWR VPWR _2209_/Y sky130_fd_sc_hd__a21oi_1
XFILLER_26_267 VGND VGND VPWR VPWR sky130_fd_sc_hd__fill_1
XFILLER_5_105 VGND VGND VPWR VPWR sky130_fd_sc_hd__decap_6
XTAP_TAPCELL_ROW_4_171 VGND VPWR sky130_fd_sc_hd__tapvpwrvgnd_1
XFILLER_17_223 VGND VGND VPWR VPWR sky130_fd_sc_hd__fill_1
XTAP_TAPCELL_ROW_27_284 VGND VPWR sky130_fd_sc_hd__tapvpwrvgnd_1
X_2491_ _2634_/CLK _2491_/D fanout174/X VGND VGND VPWR VPWR _2491_/Q sky130_fd_sc_hd__dfrtp_1
X_1511_ _2623_/Q _1514_/A1 _1491_/Y _1510_/Y VGND VGND VPWR VPWR _1511_/Y sky130_fd_sc_hd__o31ai_1
X_2560_ _2606_/CLK _2560_/D load_slew172/X VGND VGND VPWR VPWR _2560_/Q sky130_fd_sc_hd__dfrtp_1
X_1442_ _1486_/A _2283_/A _1442_/C VGND VGND VPWR VPWR _1443_/B sky130_fd_sc_hd__maj3_1
XFILLER_4_182 VGND VGND VPWR VPWR sky130_fd_sc_hd__fill_1
XFILLER_4_42 VGND VGND VPWR VPWR sky130_fd_sc_hd__fill_1
X_1373_ _2331_/B _1371_/Y _1369_/Y VGND VGND VPWR VPWR _1373_/X sky130_fd_sc_hd__a21o_1
XTAP_TAPCELL_ROW_18_240 VGND VPWR sky130_fd_sc_hd__tapvpwrvgnd_1
XFILLER_31_281 VGND VGND VPWR VPWR sky130_fd_sc_hd__decap_8
X_1709_ _2460_/Q _2402_/Q VGND VGND VPWR VPWR _2123_/B sky130_fd_sc_hd__or2_0
XTAP_TAPCELL_ROW_1_152 VGND VPWR sky130_fd_sc_hd__tapvpwrvgnd_1
Xfanout52 _1975_/B VGND VGND VPWR VPWR _1909_/B sky130_fd_sc_hd__clkdlybuf4s50_1
Xfanout63 _1947_/S VGND VGND VPWR VPWR _1917_/S sky130_fd_sc_hd__clkdlybuf4s50_1
Xfanout85 _2020_/B VGND VGND VPWR VPWR _2028_/B sky130_fd_sc_hd__clkdlybuf4s50_1
Xfanout96 _2379_/A VGND VGND VPWR VPWR _2082_/A sky130_fd_sc_hd__clkdlybuf4s50_1
Xfanout30 _1671_/Y VGND VGND VPWR VPWR _1672_/C sky130_fd_sc_hd__clkdlybuf4s50_1
XFILLER_13_84 VGND VGND VPWR VPWR sky130_fd_sc_hd__fill_1
XFILLER_49_189 VGND VGND VPWR VPWR sky130_fd_sc_hd__decap_12
XFILLER_1_163 VGND VGND VPWR VPWR sky130_fd_sc_hd__decap_4
XFILLER_29_9 VGND VGND VPWR VPWR sky130_fd_sc_hd__fill_1
X_2612_ _2633_/CLK _2612_/D fanout190/X VGND VGND VPWR VPWR _2612_/Q sky130_fd_sc_hd__dfrtp_1
Xclkload11 _2607_/CLK VGND VGND VPWR VPWR clkload11/X sky130_fd_sc_hd__clkbuf_1
XFILLER_62_3 VGND VGND VPWR VPWR sky130_fd_sc_hd__decap_4
XFILLER_13_281 VGND VGND VPWR VPWR sky130_fd_sc_hd__decap_8
X_1991_ hold329/X _2396_/Q _2020_/B VGND VGND VPWR VPWR _2571_/D sky130_fd_sc_hd__mux2_1
X_2474_ _2616_/CLK _2474_/D fanout190/X VGND VGND VPWR VPWR _2474_/Q sky130_fd_sc_hd__dfrtp_1
X_1425_ _1302_/Y _1427_/A _1393_/B VGND VGND VPWR VPWR _1426_/B sky130_fd_sc_hd__a21oi_1
X_2543_ _2592_/CLK _2543_/D load_slew147/X VGND VGND VPWR VPWR _2543_/Q sky130_fd_sc_hd__dfrtp_1
X_1287_ _1287_/A _1287_/B VGND VGND VPWR VPWR _1289_/B sky130_fd_sc_hd__nor2_1
X_1356_ _2484_/Q _1356_/B VGND VGND VPWR VPWR _1356_/X sky130_fd_sc_hd__or2_0
Xclkload5 clkload5/A VGND VGND VPWR VPWR clkload5/Y sky130_fd_sc_hd__bufinv_16
XTAP_TAPCELL_ROW_69_493 VGND VPWR sky130_fd_sc_hd__tapvpwrvgnd_1
XFILLER_6_277 VGND VGND VPWR VPWR sky130_fd_sc_hd__decap_12
X_2190_ _2190_/A _2189_/Y VGND VGND VPWR VPWR _2192_/A sky130_fd_sc_hd__nor2b_1
XFILLER_49_91 VGND VGND VPWR VPWR sky130_fd_sc_hd__fill_2
X_1210_ _1690_/A VGND VGND VPWR VPWR _2232_/A sky130_fd_sc_hd__inv_1
X_1974_ _2557_/Q _2583_/Q _1974_/S VGND VGND VPWR VPWR _1974_/Y sky130_fd_sc_hd__mux2i_1
XFILLER_45_192 VGND VGND VPWR VPWR sky130_fd_sc_hd__fill_2
X_2388_ clkload8/A _2388_/D load_slew172/X VGND VGND VPWR VPWR _2388_/Q sky130_fd_sc_hd__dfrtp_1
X_2526_ clkload2/A _2526_/D load_slew152/X VGND VGND VPWR VPWR _2526_/Q sky130_fd_sc_hd__dfrtp_1
X_1408_ _1470_/C _1408_/B VGND VGND VPWR VPWR _1416_/B sky130_fd_sc_hd__and2_0
X_2457_ clkload1/A _2457_/D load_slew150/X VGND VGND VPWR VPWR _2457_/Q sky130_fd_sc_hd__dfrtp_1
X_1339_ _1339_/A _1339_/B _1339_/C VGND VGND VPWR VPWR _1341_/B sky130_fd_sc_hd__and3_1
XFILLER_28_137 VGND VGND VPWR VPWR sky130_fd_sc_hd__decap_3
XFILLER_3_225 VGND VGND VPWR VPWR sky130_fd_sc_hd__decap_4
XFILLER_10_85 VGND VGND VPWR VPWR sky130_fd_sc_hd__fill_1
XFILLER_59_240 VGND VGND VPWR VPWR sky130_fd_sc_hd__decap_3
XFILLER_19_137 VGND VGND VPWR VPWR sky130_fd_sc_hd__decap_12
XFILLER_42_195 VGND VGND VPWR VPWR sky130_fd_sc_hd__fill_1
XFILLER_42_184 VGND VGND VPWR VPWR sky130_fd_sc_hd__fill_1
XFILLER_35_93 VGND VGND VPWR VPWR sky130_fd_sc_hd__fill_2
XFILLER_35_71 VGND VGND VPWR VPWR sky130_fd_sc_hd__fill_2
XTAP_TAPCELL_ROW_32_308 VGND VPWR sky130_fd_sc_hd__tapvpwrvgnd_1
XFILLER_27_192 VGND VGND VPWR VPWR sky130_fd_sc_hd__decap_6
X_1690_ _1690_/A _1690_/B VGND VGND VPWR VPWR _1690_/Y sky130_fd_sc_hd__xnor2_1
X_2242_ _2242_/A _2242_/B VGND VGND VPWR VPWR _2244_/B sky130_fd_sc_hd__xnor2_1
X_2311_ _2311_/A _2322_/C VGND VGND VPWR VPWR _2311_/Y sky130_fd_sc_hd__xnor2_1
XPHY_EDGE_ROW_29_Left_100 VGND VGND VPWR VPWR sky130_fd_sc_hd__decap_3
X_2173_ _2173_/A _2173_/B _2173_/C VGND VGND VPWR VPWR _2173_/Y sky130_fd_sc_hd__nor3_1
XFILLER_25_129 VGND VGND VPWR VPWR sky130_fd_sc_hd__decap_3
XTAP_TAPCELL_ROW_63_466 VGND VPWR sky130_fd_sc_hd__tapvpwrvgnd_1
X_1957_ _1957_/A _1966_/B VGND VGND VPWR VPWR _1957_/Y sky130_fd_sc_hd__nand2_1
X_2509_ _2633_/CLK _2509_/D fanout187/A VGND VGND VPWR VPWR _2509_/Q sky130_fd_sc_hd__dfrtp_1
X_1888_ _1888_/A _1954_/B VGND VGND VPWR VPWR _1888_/Y sky130_fd_sc_hd__nand2_1
XFILLER_56_26 VGND VGND VPWR VPWR sky130_fd_sc_hd__fill_2
XFILLER_16_107 VGND VGND VPWR VPWR sky130_fd_sc_hd__decap_4
XFILLER_24_195 VGND VGND VPWR VPWR sky130_fd_sc_hd__fill_1
X_1811_ _1811_/A _2490_/Q _1811_/C VGND VGND VPWR VPWR _1812_/C sky130_fd_sc_hd__maj3_1
XTAP_TAPCELL_ROW_60_447 VGND VPWR sky130_fd_sc_hd__tapvpwrvgnd_1
XFILLER_15_173 VGND VGND VPWR VPWR sky130_fd_sc_hd__decap_6
X_1673_ _2472_/Q _2471_/Q VGND VGND VPWR VPWR _1673_/Y sky130_fd_sc_hd__xnor2_1
Xhold328 _2607_/Q VGND VGND VPWR VPWR _2050_/A sky130_fd_sc_hd__dlygate4sd3_1
Xhold306 _2604_/Q VGND VGND VPWR VPWR _2044_/A sky130_fd_sc_hd__dlygate4sd3_1
Xhold317 _2585_/Q VGND VGND VPWR VPWR _2006_/A sky130_fd_sc_hd__dlygate4sd3_1
Xhold339 _2431_/Q VGND VGND VPWR VPWR hold339/X sky130_fd_sc_hd__dlygate4sd3_1
X_1742_ _2454_/Q _2396_/Q _1743_/A VGND VGND VPWR VPWR _1742_/Y sky130_fd_sc_hd__o21ai_0
X_2225_ _2360_/A _2211_/Y _2223_/X _2224_/Y VGND VGND VPWR VPWR _2225_/Y sky130_fd_sc_hd__o22ai_1
XTAP_TAPCELL_ROW_51_403 VGND VPWR sky130_fd_sc_hd__tapvpwrvgnd_1
XPHY_EDGE_ROW_5_Right_5 VGND VGND VPWR VPWR sky130_fd_sc_hd__decap_3
X_2087_ _2410_/Q _2409_/Q _2412_/Q _2411_/Q VGND VGND VPWR VPWR _2090_/B sky130_fd_sc_hd__nand4_1
X_2156_ _2330_/B _2486_/Q VGND VGND VPWR VPWR _2156_/Y sky130_fd_sc_hd__nor2_1
XFILLER_21_121 VGND VGND VPWR VPWR sky130_fd_sc_hd__decap_4
XFILLER_26_29 VGND VGND VPWR VPWR sky130_fd_sc_hd__fill_2
XFILLER_67_14 VGND VGND VPWR VPWR sky130_fd_sc_hd__decap_4
XFILLER_44_235 VGND VGND VPWR VPWR sky130_fd_sc_hd__decap_4
XFILLER_29_221 VGND VGND VPWR VPWR sky130_fd_sc_hd__decap_3
XFILLER_12_165 VGND VGND VPWR VPWR sky130_fd_sc_hd__decap_12
XFILLER_8_147 VGND VGND VPWR VPWR sky130_fd_sc_hd__decap_8
XFILLER_8_169 VGND VGND VPWR VPWR sky130_fd_sc_hd__decap_8
X_2010_ _2010_/A _2010_/B VGND VGND VPWR VPWR _2010_/Y sky130_fd_sc_hd__nor2_1
XFILLER_57_91 VGND VGND VPWR VPWR sky130_fd_sc_hd__decap_4
XFILLER_35_202 VGND VGND VPWR VPWR sky130_fd_sc_hd__decap_6
X_1725_ _2450_/Q _2392_/Q _2449_/Q _2391_/Q VGND VGND VPWR VPWR _1725_/X sky130_fd_sc_hd__a22o_1
Xclkbuf_leaf_7_clk clkload0/A VGND VGND VPWR VPWR _2633_/CLK sky130_fd_sc_hd__clkbuf_16
X_1587_ _2626_/Q _1589_/C VGND VGND VPWR VPWR _1588_/B sky130_fd_sc_hd__xnor2_1
X_1656_ _1657_/B _1657_/D _1655_/X _1654_/Y VGND VGND VPWR VPWR _2469_/D sky130_fd_sc_hd__a31oi_1
X_2139_ _1200_/Y _2472_/Q _2138_/Y _2423_/Q VGND VGND VPWR VPWR _2140_/C sky130_fd_sc_hd__a2bb2oi_1
X_2208_ _2198_/B _2224_/A2 _2207_/Y VGND VGND VPWR VPWR _2208_/Y sky130_fd_sc_hd__o21ai_0
XFILLER_53_38 VGND VGND VPWR VPWR sky130_fd_sc_hd__decap_12
XFILLER_26_279 VGND VGND VPWR VPWR sky130_fd_sc_hd__fill_1
XTAP_TAPCELL_ROW_27_285 VGND VPWR sky130_fd_sc_hd__tapvpwrvgnd_1
X_2490_ _2634_/CLK _2490_/D load_slew175/X VGND VGND VPWR VPWR _2490_/Q sky130_fd_sc_hd__dfrtp_1
XFILLER_64_7 VGND VGND VPWR VPWR sky130_fd_sc_hd__fill_1
X_1510_ _1505_/Y _1508_/Y _1509_/Y VGND VGND VPWR VPWR _1510_/Y sky130_fd_sc_hd__o21ai_0
X_1441_ _1692_/A _1420_/Y _1438_/Y _1439_/Y _1440_/Y VGND VGND VPWR VPWR _1441_/Y
+ sky130_fd_sc_hd__o221ai_1
XFILLER_4_150 VGND VGND VPWR VPWR sky130_fd_sc_hd__decap_8
X_1372_ _2331_/B _1371_/Y _1369_/Y VGND VGND VPWR VPWR _1374_/B sky130_fd_sc_hd__a21oi_1
XTAP_TAPCELL_ROW_18_241 VGND VPWR sky130_fd_sc_hd__tapvpwrvgnd_1
X_1708_ _1708_/A _2038_/B VGND VGND VPWR VPWR _1708_/Y sky130_fd_sc_hd__nor2_1
X_1639_ _2383_/A _2464_/Q VGND VGND VPWR VPWR _1639_/Y sky130_fd_sc_hd__nand2_1
XTAP_TAPCELL_ROW_1_153 VGND VPWR sky130_fd_sc_hd__tapvpwrvgnd_1
Xfanout53 _1966_/B VGND VGND VPWR VPWR _1969_/B sky130_fd_sc_hd__clkdlybuf4s50_1
Xfanout97 _2379_/A VGND VGND VPWR VPWR _1627_/A sky130_fd_sc_hd__clkdlybuf4s50_1
Xfanout75 _1543_/B VGND VGND VPWR VPWR _2096_/A sky130_fd_sc_hd__clkdlybuf4s50_1
XFILLER_13_63 VGND VGND VPWR VPWR sky130_fd_sc_hd__fill_1
Xfanout86 _2614_/Q VGND VGND VPWR VPWR _2020_/B sky130_fd_sc_hd__clkdlybuf4s50_1
XFILLER_64_138 VGND VGND VPWR VPWR sky130_fd_sc_hd__fill_2
XFILLER_38_82 VGND VGND VPWR VPWR sky130_fd_sc_hd__fill_2
X_1990_ hold311/X _2395_/Q _2028_/B VGND VGND VPWR VPWR _1990_/X sky130_fd_sc_hd__mux2_1
XTAP_TAPCELL_ROW_15_222 VGND VPWR sky130_fd_sc_hd__tapvpwrvgnd_1
XFILLER_55_3 VGND VGND VPWR VPWR sky130_fd_sc_hd__decap_6
Xclkload12 _2606_/CLK VGND VGND VPWR VPWR clkload12/X sky130_fd_sc_hd__clkbuf_8
X_2542_ _2592_/CLK _2542_/D fanout148/X VGND VGND VPWR VPWR _2542_/Q sky130_fd_sc_hd__dfrtp_1
X_2611_ clkload4/A _2611_/D fanout157/A VGND VGND VPWR VPWR _2611_/Q sky130_fd_sc_hd__dfrtp_1
X_2473_ _2616_/CLK _2473_/D fanout190/X VGND VGND VPWR VPWR _2473_/Q sky130_fd_sc_hd__dfrtp_1
X_1424_ _2257_/B _2230_/B VGND VGND VPWR VPWR _1426_/A sky130_fd_sc_hd__xnor2_1
X_1355_ _2356_/A _1355_/B VGND VGND VPWR VPWR _1356_/B sky130_fd_sc_hd__xnor2_1
XFILLER_70_108 VGND VGND VPWR VPWR sky130_fd_sc_hd__fill_1
X_1286_ _2201_/A _2176_/A VGND VGND VPWR VPWR _1287_/B sky130_fd_sc_hd__and2_0
XFILLER_50_39 VGND VGND VPWR VPWR sky130_fd_sc_hd__decap_8
XTAP_TAPCELL_ROW_46_380 VGND VPWR sky130_fd_sc_hd__tapvpwrvgnd_1
Xclkload6 clkload6/A VGND VGND VPWR VPWR clkload6/X sky130_fd_sc_hd__clkbuf_1
XFILLER_11_219 VGND VGND VPWR VPWR sky130_fd_sc_hd__decap_4
XTAP_TAPCELL_ROW_69_494 VGND VPWR sky130_fd_sc_hd__tapvpwrvgnd_1
XFILLER_46_105 VGND VGND VPWR VPWR sky130_fd_sc_hd__decap_3
XFILLER_61_119 VGND VGND VPWR VPWR sky130_fd_sc_hd__fill_1
XFILLER_40_72 VGND VGND VPWR VPWR sky130_fd_sc_hd__decap_3
XFILLER_6_223 VGND VGND VPWR VPWR sky130_fd_sc_hd__fill_1
XFILLER_65_91 VGND VGND VPWR VPWR sky130_fd_sc_hd__fill_1
X_1973_ _1975_/B _1971_/Y _1972_/Y VGND VGND VPWR VPWR _1973_/Y sky130_fd_sc_hd__o21ai_0
XFILLER_60_141 VGND VGND VPWR VPWR sky130_fd_sc_hd__fill_2
X_2525_ clkload1/A _2525_/D load_slew152/X VGND VGND VPWR VPWR _2525_/Q sky130_fd_sc_hd__dfrtp_1
XFILLER_68_285 VGND VGND VPWR VPWR sky130_fd_sc_hd__decap_4
X_2387_ clkload8/A _2387_/D load_slew172/X VGND VGND VPWR VPWR _2387_/Q sky130_fd_sc_hd__dfrtp_1
X_1338_ _2481_/Q _1332_/B _1337_/Y _2274_/A VGND VGND VPWR VPWR _1338_/Y sky130_fd_sc_hd__a22oi_1
X_2456_ clkload1/A _2456_/D load_slew150/X VGND VGND VPWR VPWR _2456_/Q sky130_fd_sc_hd__dfrtp_1
X_1407_ _1407_/A _1407_/B VGND VGND VPWR VPWR _1416_/A sky130_fd_sc_hd__nor2_1
X_1269_ _2185_/B _2171_/A _2187_/B VGND VGND VPWR VPWR _1269_/Y sky130_fd_sc_hd__o21ai_0
XFILLER_51_141 VGND VGND VPWR VPWR sky130_fd_sc_hd__decap_4
XFILLER_43_108 VGND VGND VPWR VPWR sky130_fd_sc_hd__decap_4
XFILLER_51_185 VGND VGND VPWR VPWR sky130_fd_sc_hd__fill_2
XFILLER_19_73 VGND VGND VPWR VPWR sky130_fd_sc_hd__fill_2
XFILLER_19_95 VGND VGND VPWR VPWR sky130_fd_sc_hd__fill_1
XFILLER_19_105 VGND VGND VPWR VPWR sky130_fd_sc_hd__decap_6
XFILLER_19_149 VGND VGND VPWR VPWR sky130_fd_sc_hd__decap_8
XTAP_TAPCELL_ROW_32_309 VGND VPWR sky130_fd_sc_hd__tapvpwrvgnd_1
XFILLER_51_71 VGND VGND VPWR VPWR sky130_fd_sc_hd__fill_1
X_2172_ _2297_/A _2191_/B VGND VGND VPWR VPWR _2173_/C sky130_fd_sc_hd__nor2_1
X_2241_ _2242_/A _2241_/B VGND VGND VPWR VPWR _2260_/A sky130_fd_sc_hd__nor2_1
X_2310_ _2295_/A _2295_/B _2294_/B _2291_/Y VGND VGND VPWR VPWR _2322_/C sky130_fd_sc_hd__o31a_1
XFILLER_65_288 VGND VGND VPWR VPWR sky130_fd_sc_hd__fill_1
X_1887_ _2528_/Q _2602_/Q _1956_/S VGND VGND VPWR VPWR _1887_/Y sky130_fd_sc_hd__mux2i_1
X_1956_ _2551_/Q _2577_/Q _1956_/S VGND VGND VPWR VPWR _1956_/Y sky130_fd_sc_hd__mux2i_1
XFILLER_33_185 VGND VGND VPWR VPWR sky130_fd_sc_hd__decap_12
X_2508_ _2633_/CLK _2508_/D fanout187/X VGND VGND VPWR VPWR _2508_/Q sky130_fd_sc_hd__dfrtp_1
XFILLER_0_218 VGND VGND VPWR VPWR sky130_fd_sc_hd__decap_6
XFILLER_56_38 VGND VGND VPWR VPWR sky130_fd_sc_hd__fill_1
X_2439_ clkload5/A _2439_/D load_slew162/X VGND VGND VPWR VPWR _2439_/Q sky130_fd_sc_hd__dfrtp_1
XFILLER_24_141 VGND VGND VPWR VPWR sky130_fd_sc_hd__fill_1
Xmax_cap83 _1269_/Y VGND VGND VPWR VPWR _1275_/B sky130_fd_sc_hd__clkdlybuf4s25_1
X_1810_ _1810_/A _2489_/Q _1810_/C VGND VGND VPWR VPWR _1811_/C sky130_fd_sc_hd__maj3_1
XTAP_TAPCELL_ROW_60_448 VGND VPWR sky130_fd_sc_hd__tapvpwrvgnd_1
XFILLER_30_122 VGND VGND VPWR VPWR sky130_fd_sc_hd__fill_2
X_1741_ _2121_/B _1741_/B VGND VGND VPWR VPWR _1741_/Y sky130_fd_sc_hd__nor2_1
X_1672_ _2471_/Q _1672_/B _1672_/C VGND VGND VPWR VPWR _2471_/D sky130_fd_sc_hd__nand3_1
Xhold318 _2488_/Q VGND VGND VPWR VPWR hold318/X sky130_fd_sc_hd__dlygate4sd3_1
XFILLER_7_98 VGND VGND VPWR VPWR sky130_fd_sc_hd__fill_1
Xhold329 _2571_/Q VGND VGND VPWR VPWR hold329/X sky130_fd_sc_hd__dlygate4sd3_1
Xhold307 _2597_/Q VGND VGND VPWR VPWR _2030_/A sky130_fd_sc_hd__dlygate4sd3_1
X_2224_ _2176_/A _2224_/A2 _2360_/A VGND VGND VPWR VPWR _2224_/Y sky130_fd_sc_hd__o21ai_0
XFILLER_38_211 VGND VGND VPWR VPWR sky130_fd_sc_hd__decap_8
X_2155_ _2155_/A VGND VGND VPWR VPWR _2155_/Y sky130_fd_sc_hd__inv_1
XFILLER_53_236 VGND VGND VPWR VPWR sky130_fd_sc_hd__fill_2
XTAP_TAPCELL_ROW_51_404 VGND VPWR sky130_fd_sc_hd__tapvpwrvgnd_1
X_2086_ _1262_/C _2082_/B _2412_/Q VGND VGND VPWR VPWR _2088_/A sky130_fd_sc_hd__o21bai_1
X_1939_ _1939_/A _1942_/B VGND VGND VPWR VPWR _1939_/Y sky130_fd_sc_hd__nand2_1
XPHY_EDGE_ROW_48_Left_119 VGND VGND VPWR VPWR sky130_fd_sc_hd__decap_3
XFILLER_29_288 VGND VGND VPWR VPWR sky130_fd_sc_hd__fill_1
XPHY_EDGE_ROW_57_Left_128 VGND VGND VPWR VPWR sky130_fd_sc_hd__decap_3
XFILLER_32_51 VGND VGND VPWR VPWR sky130_fd_sc_hd__fill_1
XFILLER_8_137 VGND VGND VPWR VPWR sky130_fd_sc_hd__decap_3
XPHY_EDGE_ROW_11_Right_11 VGND VGND VPWR VPWR sky130_fd_sc_hd__decap_3
XFILLER_12_177 VGND VGND VPWR VPWR sky130_fd_sc_hd__decap_12
XFILLER_16_85 VGND VGND VPWR VPWR sky130_fd_sc_hd__fill_2
XPHY_EDGE_ROW_20_Right_20 VGND VGND VPWR VPWR sky130_fd_sc_hd__decap_3
XPHY_EDGE_ROW_66_Left_137 VGND VGND VPWR VPWR sky130_fd_sc_hd__decap_3
XFILLER_7_181 VGND VGND VPWR VPWR sky130_fd_sc_hd__fill_2
X_1724_ _2449_/Q _2391_/Q VGND VGND VPWR VPWR _2124_/C sky130_fd_sc_hd__or2_0
X_1586_ _1603_/A _1589_/C _1586_/C VGND VGND VPWR VPWR _2625_/D sky130_fd_sc_hd__nor3_1
X_1655_ _2077_/B _1648_/Y _1657_/C VGND VGND VPWR VPWR _1655_/X sky130_fd_sc_hd__mux2_1
X_2138_ _1200_/Y _2472_/Q _2471_/Q VGND VGND VPWR VPWR _2138_/Y sky130_fd_sc_hd__a21oi_1
X_2207_ _2224_/A2 _2206_/Y _2365_/B1 VGND VGND VPWR VPWR _2207_/Y sky130_fd_sc_hd__a21oi_1
X_2069_ _2459_/Q hold363/X _2074_/S VGND VGND VPWR VPWR _2069_/X sky130_fd_sc_hd__mux2_1
XFILLER_17_225 VGND VGND VPWR VPWR sky130_fd_sc_hd__decap_3
XTAP_TAPCELL_ROW_27_286 VGND VPWR sky130_fd_sc_hd__tapvpwrvgnd_1
XFILLER_43_83 VGND VGND VPWR VPWR sky130_fd_sc_hd__fill_1
XFILLER_67_103 VGND VGND VPWR VPWR sky130_fd_sc_hd__fill_2
X_1440_ _1690_/A _1440_/B VGND VGND VPWR VPWR _1440_/Y sky130_fd_sc_hd__nand2_1
XFILLER_4_195 VGND VGND VPWR VPWR sky130_fd_sc_hd__fill_1
XFILLER_4_66 VGND VGND VPWR VPWR sky130_fd_sc_hd__fill_2
XTAP_TAPCELL_ROW_10_197 VGND VPWR sky130_fd_sc_hd__tapvpwrvgnd_1
X_1371_ _1371_/A _1371_/B VGND VGND VPWR VPWR _1371_/Y sky130_fd_sc_hd__nand2_1
XFILLER_16_280 VGND VGND VPWR VPWR sky130_fd_sc_hd__decap_8
X_1638_ _1243_/Y _1637_/Y _1638_/S VGND VGND VPWR VPWR _2462_/D sky130_fd_sc_hd__mux2i_1
X_1707_ _2096_/A _1707_/B VGND VGND VPWR VPWR _2486_/D sky130_fd_sc_hd__nor2_1
X_1569_ _1977_/B _1569_/B VGND VGND VPWR VPWR _2618_/D sky130_fd_sc_hd__nor2_1
Xfanout21 _2167_/X VGND VGND VPWR VPWR _2351_/B sky130_fd_sc_hd__clkdlybuf4s50_1
XTAP_TAPCELL_ROW_1_154 VGND VPWR sky130_fd_sc_hd__tapvpwrvgnd_1
Xfanout10 _2380_/S VGND VGND VPWR VPWR _1624_/S sky130_fd_sc_hd__clkdlybuf4s50_1
XFILLER_14_217 VGND VGND VPWR VPWR sky130_fd_sc_hd__decap_4
Xfanout54 _1975_/B VGND VGND VPWR VPWR _1966_/B sky130_fd_sc_hd__clkdlybuf4s50_1
Xfanout65 _1971_/S VGND VGND VPWR VPWR _1956_/S sky130_fd_sc_hd__clkdlybuf4s50_1
Xfanout98 _2379_/A VGND VGND VPWR VPWR _2383_/A sky130_fd_sc_hd__clkdlybuf4s50_1
Xfanout76 _1543_/B VGND VGND VPWR VPWR _2327_/B sky130_fd_sc_hd__clkdlybuf4s50_1
XTAP_TAPCELL_ROW_24_267 VGND VPWR sky130_fd_sc_hd__tapvpwrvgnd_1
Xfanout87 _2034_/B VGND VGND VPWR VPWR _2032_/B sky130_fd_sc_hd__clkdlybuf4s50_1
XFILLER_1_121 VGND VGND VPWR VPWR sky130_fd_sc_hd__fill_2
XTAP_TAPCELL_ROW_15_223 VGND VPWR sky130_fd_sc_hd__tapvpwrvgnd_1
X_2472_ _2616_/CLK _2472_/D fanout190/X VGND VGND VPWR VPWR _2472_/Q sky130_fd_sc_hd__dfrtp_1
Xclkload13 _2616_/CLK VGND VGND VPWR VPWR clkload13/Y sky130_fd_sc_hd__inv_6
X_2610_ clkload5/A _2610_/D fanout157/A VGND VGND VPWR VPWR _2610_/Q sky130_fd_sc_hd__dfrtp_1
X_2541_ _2592_/CLK _2541_/D fanout148/X VGND VGND VPWR VPWR _2541_/Q sky130_fd_sc_hd__dfrtp_1
X_1285_ _2201_/A _2176_/A VGND VGND VPWR VPWR _1287_/A sky130_fd_sc_hd__nor2_1
XFILLER_48_3 VGND VGND VPWR VPWR sky130_fd_sc_hd__decap_6
X_1423_ _1423_/A _1423_/B VGND VGND VPWR VPWR _1423_/Y sky130_fd_sc_hd__xnor2_1
X_1354_ _1343_/X _1357_/A VGND VGND VPWR VPWR _1355_/B sky130_fd_sc_hd__nand2b_1
XFILLER_63_183 VGND VGND VPWR VPWR sky130_fd_sc_hd__decap_4
XFILLER_55_117 VGND VGND VPWR VPWR sky130_fd_sc_hd__fill_1
XTAP_TAPCELL_ROW_46_381 VGND VPWR sky130_fd_sc_hd__tapvpwrvgnd_1
XTAP_TAPCELL_ROW_38_337 VGND VPWR sky130_fd_sc_hd__tapvpwrvgnd_1
XFILLER_50_29 VGND VGND VPWR VPWR sky130_fd_sc_hd__fill_2
Xclkload7 clkload7/A VGND VGND VPWR VPWR clkload7/Y sky130_fd_sc_hd__inv_16
XTAP_TAPCELL_ROW_69_495 VGND VPWR sky130_fd_sc_hd__tapvpwrvgnd_1
XFILLER_46_139 VGND VGND VPWR VPWR sky130_fd_sc_hd__fill_1
XFILLER_39_180 VGND VGND VPWR VPWR sky130_fd_sc_hd__decap_3
XFILLER_54_183 VGND VGND VPWR VPWR sky130_fd_sc_hd__decap_12
XFILLER_24_41 VGND VGND VPWR VPWR sky130_fd_sc_hd__decap_12
XFILLER_24_85 VGND VGND VPWR VPWR sky130_fd_sc_hd__fill_1
XFILLER_10_253 VGND VGND VPWR VPWR sky130_fd_sc_hd__decap_3
XFILLER_69_209 VGND VGND VPWR VPWR sky130_fd_sc_hd__decap_3
X_1972_ _1972_/A _1975_/B VGND VGND VPWR VPWR _1972_/Y sky130_fd_sc_hd__nand2_1
XFILLER_60_197 VGND VGND VPWR VPWR sky130_fd_sc_hd__decap_4
XTAP_TAPCELL_ROW_43_362 VGND VPWR sky130_fd_sc_hd__tapvpwrvgnd_1
XPHY_EDGE_ROW_49_Right_49 VGND VGND VPWR VPWR sky130_fd_sc_hd__decap_3
X_2455_ clkload6/A _2455_/D fanout141/X VGND VGND VPWR VPWR _2455_/Q sky130_fd_sc_hd__dfrtp_1
X_2524_ clkload1/A _2524_/D load_slew152/X VGND VGND VPWR VPWR _2524_/Q sky130_fd_sc_hd__dfrtp_1
XFILLER_68_264 VGND VGND VPWR VPWR sky130_fd_sc_hd__fill_1
XFILLER_68_253 VGND VGND VPWR VPWR sky130_fd_sc_hd__decap_3
X_1268_ _2198_/B _2185_/B VGND VGND VPWR VPWR _1275_/A sky130_fd_sc_hd__xnor2_1
XPHY_EDGE_ROW_58_Right_58 VGND VGND VPWR VPWR sky130_fd_sc_hd__decap_3
X_2386_ clkload8/A _2386_/D load_slew172/X VGND VGND VPWR VPWR _2386_/Q sky130_fd_sc_hd__dfrtp_1
X_1337_ _1339_/C _1337_/B VGND VGND VPWR VPWR _1337_/Y sky130_fd_sc_hd__xnor2_1
X_1406_ _1407_/A _1406_/B VGND VGND VPWR VPWR _1418_/A sky130_fd_sc_hd__nand2b_1
X_1199_ _2185_/B VGND VGND VPWR VPWR _2201_/B sky130_fd_sc_hd__inv_1
XFILLER_51_153 VGND VGND VPWR VPWR sky130_fd_sc_hd__decap_12
XPHY_EDGE_ROW_67_Right_67 VGND VGND VPWR VPWR sky130_fd_sc_hd__decap_3
XTAP_TAPCELL_ROW_57_432 VGND VPWR sky130_fd_sc_hd__tapvpwrvgnd_1
XFILLER_51_61 VGND VGND VPWR VPWR sky130_fd_sc_hd__fill_2
XFILLER_42_197 VGND VGND VPWR VPWR sky130_fd_sc_hd__fill_1
XFILLER_35_84 VGND VGND VPWR VPWR sky130_fd_sc_hd__fill_1
X_2171_ _2171_/A _2171_/B VGND VGND VPWR VPWR _2191_/B sky130_fd_sc_hd__nand2_1
X_2240_ _2198_/A _2477_/Q _2255_/B VGND VGND VPWR VPWR _2240_/Y sky130_fd_sc_hd__mux2i_1
XPHY_EDGE_ROW_27_Left_98 VGND VGND VPWR VPWR sky130_fd_sc_hd__decap_3
XFILLER_33_197 VGND VGND VPWR VPWR sky130_fd_sc_hd__fill_1
XFILLER_18_172 VGND VGND VPWR VPWR sky130_fd_sc_hd__decap_12
X_1886_ _1954_/B _1884_/Y _1885_/Y VGND VGND VPWR VPWR _1886_/Y sky130_fd_sc_hd__o21ai_0
X_1955_ _1954_/B _1953_/Y _1954_/Y VGND VGND VPWR VPWR _2551_/D sky130_fd_sc_hd__o21ai_0
X_2507_ _2607_/CLK _2507_/D fanout187/X VGND VGND VPWR VPWR _2507_/Q sky130_fd_sc_hd__dfrtp_1
X_2438_ clkload4/A _2438_/D fanout157/X VGND VGND VPWR VPWR _2438_/Q sky130_fd_sc_hd__dfstp_2
XFILLER_56_245 VGND VGND VPWR VPWR sky130_fd_sc_hd__decap_6
XFILLER_56_234 VGND VGND VPWR VPWR sky130_fd_sc_hd__decap_6
X_2369_ _2609_/Q _2610_/Q _2368_/Y VGND VGND VPWR VPWR _2369_/Y sky130_fd_sc_hd__o21ai_0
XFILLER_24_197 VGND VGND VPWR VPWR sky130_fd_sc_hd__decap_4
XFILLER_47_256 VGND VGND VPWR VPWR sky130_fd_sc_hd__decap_3
XFILLER_47_223 VGND VGND VPWR VPWR sky130_fd_sc_hd__fill_1
XFILLER_70_281 VGND VGND VPWR VPWR sky130_fd_sc_hd__decap_8
XFILLER_46_50 VGND VGND VPWR VPWR sky130_fd_sc_hd__decap_3
Xmax_cap40 _1474_/Y VGND VGND VPWR VPWR _1516_/B sky130_fd_sc_hd__clkdlybuf4s25_1
Xmax_cap73 _2108_/A VGND VGND VPWR VPWR _1550_/B sky130_fd_sc_hd__clkdlybuf4s25_1
XTAP_TAPCELL_ROW_60_449 VGND VPWR sky130_fd_sc_hd__tapvpwrvgnd_1
XFILLER_30_167 VGND VGND VPWR VPWR sky130_fd_sc_hd__decap_8
XFILLER_7_11 VGND VGND VPWR VPWR sky130_fd_sc_hd__fill_1
Xhold308 _2545_/Q VGND VGND VPWR VPWR _1936_/A sky130_fd_sc_hd__dlygate4sd3_1
X_1671_ _2332_/A _2318_/A _1671_/C VGND VGND VPWR VPWR _1671_/Y sky130_fd_sc_hd__nand3_1
X_1740_ _1740_/A _1740_/B VGND VGND VPWR VPWR _1741_/B sky130_fd_sc_hd__nand2_1
Xhold319 _2584_/Q VGND VGND VPWR VPWR _2004_/A sky130_fd_sc_hd__dlygate4sd3_1
XFILLER_30_3 VGND VGND VPWR VPWR sky130_fd_sc_hd__decap_4
X_2223_ _2229_/B _2222_/X _2224_/A2 VGND VGND VPWR VPWR _2223_/X sky130_fd_sc_hd__o21a_1
XFILLER_53_204 VGND VGND VPWR VPWR sky130_fd_sc_hd__fill_1
XFILLER_38_267 VGND VGND VPWR VPWR sky130_fd_sc_hd__decap_3
XFILLER_38_245 VGND VGND VPWR VPWR sky130_fd_sc_hd__fill_2
X_2085_ _1264_/A _2080_/Y _2083_/X _1262_/C VGND VGND VPWR VPWR _2411_/D sky130_fd_sc_hd__o22ai_1
X_2154_ _2330_/B _2486_/Q _1371_/B VGND VGND VPWR VPWR _2155_/A sky130_fd_sc_hd__a21oi_1
XTAP_TAPCELL_ROW_51_405 VGND VPWR sky130_fd_sc_hd__tapvpwrvgnd_1
XFILLER_21_101 VGND VGND VPWR VPWR sky130_fd_sc_hd__decap_3
X_1869_ _1867_/A _2028_/A _1944_/S VGND VGND VPWR VPWR _1869_/Y sky130_fd_sc_hd__mux2i_1
X_1938_ _2545_/Q _2571_/Q _1944_/S VGND VGND VPWR VPWR _1938_/Y sky130_fd_sc_hd__mux2i_1
XFILLER_29_201 VGND VGND VPWR VPWR sky130_fd_sc_hd__decap_12
XFILLER_44_226 VGND VGND VPWR VPWR sky130_fd_sc_hd__fill_2
XFILLER_29_267 VGND VGND VPWR VPWR sky130_fd_sc_hd__fill_2
XFILLER_12_101 VGND VGND VPWR VPWR sky130_fd_sc_hd__decap_12
XFILLER_16_64 VGND VGND VPWR VPWR sky130_fd_sc_hd__fill_1
XFILLER_16_75 VGND VGND VPWR VPWR sky130_fd_sc_hd__fill_2
XFILLER_32_85 VGND VGND VPWR VPWR sky130_fd_sc_hd__decap_4
XFILLER_12_189 VGND VGND VPWR VPWR sky130_fd_sc_hd__decap_6
XTAP_TAPCELL_ROW_7_182 VGND VPWR sky130_fd_sc_hd__tapvpwrvgnd_1
XFILLER_43_281 VGND VGND VPWR VPWR sky130_fd_sc_hd__decap_8
X_1654_ _1657_/C _1657_/D _1648_/Y _1657_/B VGND VGND VPWR VPWR _1654_/Y sky130_fd_sc_hd__a31oi_1
X_1723_ _2448_/Q _2390_/Q _1723_/C VGND VGND VPWR VPWR _1723_/X sky130_fd_sc_hd__maj3_1
X_2206_ _2206_/A _2206_/B VGND VGND VPWR VPWR _2206_/Y sky130_fd_sc_hd__xnor2_1
X_1585_ _2625_/Q _1585_/B VGND VGND VPWR VPWR _1586_/C sky130_fd_sc_hd__nor2_1
X_2137_ _2137_/A _2474_/Q VGND VGND VPWR VPWR _2191_/A sky130_fd_sc_hd__nor2_1
XFILLER_41_207 VGND VGND VPWR VPWR sky130_fd_sc_hd__decap_6
X_2068_ _2458_/Q _2400_/Q _2076_/S VGND VGND VPWR VPWR _2400_/D sky130_fd_sc_hd__mux2_1
XFILLER_26_204 VGND VGND VPWR VPWR sky130_fd_sc_hd__fill_1
XPHY_EDGE_ROW_14_Left_85 VGND VGND VPWR VPWR sky130_fd_sc_hd__decap_3
XTAP_TAPCELL_ROW_70_500 VGND VPWR sky130_fd_sc_hd__tapvpwrvgnd_1
XFILLER_40_251 VGND VGND VPWR VPWR sky130_fd_sc_hd__fill_1
XFILLER_43_95 VGND VGND VPWR VPWR sky130_fd_sc_hd__fill_2
XFILLER_40_284 VGND VGND VPWR VPWR sky130_fd_sc_hd__decap_4
XFILLER_4_141 VGND VGND VPWR VPWR sky130_fd_sc_hd__fill_1
XTAP_TAPCELL_ROW_10_198 VGND VPWR sky130_fd_sc_hd__tapvpwrvgnd_1
Xload_slew6 _2060_/S VGND VGND VPWR VPWR _2067_/S sky130_fd_sc_hd__buf_4
XFILLER_4_34 VGND VGND VPWR VPWR sky130_fd_sc_hd__decap_8
XFILLER_4_23 VGND VGND VPWR VPWR sky130_fd_sc_hd__decap_4
X_1370_ _2158_/B _2318_/A VGND VGND VPWR VPWR _1371_/B sky130_fd_sc_hd__nor2b_1
XFILLER_31_262 VGND VGND VPWR VPWR sky130_fd_sc_hd__decap_12
X_1637_ _2383_/A _2463_/Q VGND VGND VPWR VPWR _1637_/Y sky130_fd_sc_hd__nand2_1
X_1706_ _2318_/A _1671_/C _2332_/A VGND VGND VPWR VPWR _1707_/B sky130_fd_sc_hd__a21oi_1
X_1568_ _2618_/Q _2617_/Q VGND VGND VPWR VPWR _1569_/B sky130_fd_sc_hd__xnor2_1
X_1499_ _2187_/B _1497_/Y _1498_/Y VGND VGND VPWR VPWR _1500_/B sky130_fd_sc_hd__a21oi_1
Xfanout55 _1834_/Y VGND VGND VPWR VPWR _1975_/B sky130_fd_sc_hd__clkdlybuf4s50_1
Xfanout22 _2167_/X VGND VGND VPWR VPWR _2283_/B sky130_fd_sc_hd__clkdlybuf4s50_1
Xfanout44 _1942_/B VGND VGND VPWR VPWR _1933_/B sky130_fd_sc_hd__clkdlybuf4s50_1
XTAP_TAPCELL_ROW_1_155 VGND VPWR sky130_fd_sc_hd__tapvpwrvgnd_1
XTAP_TAPCELL_ROW_24_268 VGND VPWR sky130_fd_sc_hd__tapvpwrvgnd_1
Xfanout88 _2614_/Q VGND VGND VPWR VPWR _2034_/B sky130_fd_sc_hd__clkdlybuf4s50_1
Xfanout99 _2611_/Q VGND VGND VPWR VPWR _2379_/A sky130_fd_sc_hd__clkdlybuf4s50_1
XFILLER_13_32 VGND VGND VPWR VPWR sky130_fd_sc_hd__decap_4
Xfanout77 _2196_/B VGND VGND VPWR VPWR _1543_/B sky130_fd_sc_hd__clkdlybuf4s50_1
XFILLER_1_111 VGND VGND VPWR VPWR sky130_fd_sc_hd__fill_1
XFILLER_8_3 VGND VGND VPWR VPWR sky130_fd_sc_hd__decap_12
XTAP_TAPCELL_ROW_15_224 VGND VPWR sky130_fd_sc_hd__tapvpwrvgnd_1
XFILLER_70_93 VGND VGND VPWR VPWR sky130_fd_sc_hd__decap_3
X_2471_ _2616_/CLK _2471_/D fanout190/X VGND VGND VPWR VPWR _2471_/Q sky130_fd_sc_hd__dfrtp_1
X_1422_ wire36/X _1422_/B VGND VGND VPWR VPWR _1440_/B sky130_fd_sc_hd__xnor2_1
X_2540_ clkload5/A _2540_/D load_slew154/X VGND VGND VPWR VPWR _2540_/Q sky130_fd_sc_hd__dfrtp_1
X_1284_ _2474_/Q _1274_/Y _1275_/Y _2473_/Q VGND VGND VPWR VPWR _1284_/Y sky130_fd_sc_hd__a22oi_1
X_1353_ _1357_/B _1352_/Y VGND VGND VPWR VPWR _2356_/A sky130_fd_sc_hd__nor2b_1
XFILLER_48_192 VGND VGND VPWR VPWR sky130_fd_sc_hd__decap_4
XTAP_TAPCELL_ROW_38_338 VGND VPWR sky130_fd_sc_hd__tapvpwrvgnd_1
Xclkload8 clkload8/A VGND VGND VPWR VPWR clkload8/X sky130_fd_sc_hd__clkbuf_8
XTAP_TAPCELL_ROW_69_496 VGND VPWR sky130_fd_sc_hd__tapvpwrvgnd_1
XFILLER_54_162 VGND VGND VPWR VPWR sky130_fd_sc_hd__fill_1
XFILLER_54_195 VGND VGND VPWR VPWR sky130_fd_sc_hd__fill_1
XFILLER_10_210 VGND VGND VPWR VPWR sky130_fd_sc_hd__fill_1
XFILLER_24_53 VGND VGND VPWR VPWR sky130_fd_sc_hd__decap_8
XFILLER_40_96 VGND VGND VPWR VPWR sky130_fd_sc_hd__fill_2
XFILLER_40_85 VGND VGND VPWR VPWR sky130_fd_sc_hd__decap_3
XFILLER_6_247 VGND VGND VPWR VPWR sky130_fd_sc_hd__fill_1
XFILLER_10_265 VGND VGND VPWR VPWR sky130_fd_sc_hd__fill_2
XFILLER_10_287 VGND VGND VPWR VPWR sky130_fd_sc_hd__fill_2
X_1971_ _2556_/Q _2582_/Q _1971_/S VGND VGND VPWR VPWR _1971_/Y sky130_fd_sc_hd__mux2i_1
XFILLER_60_3 VGND VGND VPWR VPWR sky130_fd_sc_hd__decap_12
XTAP_TAPCELL_ROW_43_363 VGND VPWR sky130_fd_sc_hd__tapvpwrvgnd_1
X_2385_ clkload8/A _2385_/D load_slew172/X VGND VGND VPWR VPWR _2385_/Q sky130_fd_sc_hd__dfrtp_1
X_2523_ clkload6/A _2523_/D load_slew142/X VGND VGND VPWR VPWR _2523_/Q sky130_fd_sc_hd__dfrtp_1
X_2454_ clkload6/A _2454_/D fanout141/X VGND VGND VPWR VPWR _2454_/Q sky130_fd_sc_hd__dfrtp_1
X_1405_ _1445_/A _1417_/A2 _1406_/B _1379_/Y VGND VGND VPWR VPWR _1407_/B sky130_fd_sc_hd__o211a_1
Xinput1 rst_n VGND VGND VPWR VPWR input1/X sky130_fd_sc_hd__clkdlybuf4s50_1
XTAP_TAPCELL_ROW_66_477 VGND VPWR sky130_fd_sc_hd__tapvpwrvgnd_1
X_1267_ _2198_/B _2185_/B VGND VGND VPWR VPWR _1472_/A sky130_fd_sc_hd__nor2_1
X_1198_ _2198_/B VGND VGND VPWR VPWR _2137_/A sky130_fd_sc_hd__inv_1
X_1336_ _1485_/A _1331_/B _1339_/A VGND VGND VPWR VPWR _1337_/B sky130_fd_sc_hd__o21ai_0
XFILLER_51_132 VGND VGND VPWR VPWR sky130_fd_sc_hd__fill_1
XFILLER_36_173 VGND VGND VPWR VPWR sky130_fd_sc_hd__decap_6
XFILLER_59_232 VGND VGND VPWR VPWR sky130_fd_sc_hd__decap_8
XTAP_TAPCELL_ROW_57_433 VGND VPWR sky130_fd_sc_hd__tapvpwrvgnd_1
XPHY_EDGE_ROW_2_Left_73 VGND VGND VPWR VPWR sky130_fd_sc_hd__decap_3
XFILLER_65_279 VGND VGND VPWR VPWR sky130_fd_sc_hd__fill_1
X_2170_ _2283_/B _2171_/B _2171_/A VGND VGND VPWR VPWR _2173_/B sky130_fd_sc_hd__a21oi_1
X_1954_ _1954_/A _1954_/B VGND VGND VPWR VPWR _1954_/Y sky130_fd_sc_hd__nand2_1
XFILLER_18_184 VGND VGND VPWR VPWR sky130_fd_sc_hd__fill_2
XFILLER_18_195 VGND VGND VPWR VPWR sky130_fd_sc_hd__fill_1
X_1885_ _1885_/A _1954_/B VGND VGND VPWR VPWR _1885_/Y sky130_fd_sc_hd__nand2_1
X_2506_ _2607_/CLK _2506_/D fanout187/X VGND VGND VPWR VPWR _2506_/Q sky130_fd_sc_hd__dfrtp_1
XFILLER_0_209 VGND VGND VPWR VPWR sky130_fd_sc_hd__fill_1
X_2437_ clkload4/A _2437_/D _2437_/SET_B VGND VGND VPWR VPWR _2437_/Q sky130_fd_sc_hd__dfstp_2
X_2368_ _2610_/Q _1454_/X _1466_/B VGND VGND VPWR VPWR _2368_/Y sky130_fd_sc_hd__a21oi_1
X_1319_ _1519_/A _2272_/B _1315_/Y VGND VGND VPWR VPWR _1320_/B sky130_fd_sc_hd__o21ai_0
X_2299_ _2360_/A _2286_/Y _2297_/Y _2298_/Y VGND VGND VPWR VPWR _2299_/Y sky130_fd_sc_hd__o22ai_1
XFILLER_47_279 VGND VGND VPWR VPWR sky130_fd_sc_hd__fill_1
XFILLER_47_202 VGND VGND VPWR VPWR sky130_fd_sc_hd__decap_3
XFILLER_46_40 VGND VGND VPWR VPWR sky130_fd_sc_hd__decap_6
Xmax_cap74 _1496_/A VGND VGND VPWR VPWR _1477_/B sky130_fd_sc_hd__buf_1
Xmax_cap41 _1315_/B VGND VGND VPWR VPWR _1340_/B sky130_fd_sc_hd__clkdlybuf4s25_1
Xhold309 _2594_/Q VGND VGND VPWR VPWR _2024_/A sky130_fd_sc_hd__dlygate4sd3_1
X_1670_ _2307_/A _1702_/B VGND VGND VPWR VPWR _1671_/C sky130_fd_sc_hd__nor2_1
X_2222_ _2222_/A _2222_/B _2222_/C VGND VGND VPWR VPWR _2222_/X sky130_fd_sc_hd__and3_1
XFILLER_23_3 VGND VGND VPWR VPWR sky130_fd_sc_hd__decap_4
X_2084_ _1218_/Y _2079_/Y _2083_/X VGND VGND VPWR VPWR _2410_/D sky130_fd_sc_hd__a21oi_1
X_2153_ _2273_/A _2149_/B _2152_/Y _2305_/B _2151_/Y VGND VGND VPWR VPWR _2153_/Y
+ sky130_fd_sc_hd__o221ai_1
XTAP_TAPCELL_ROW_51_406 VGND VPWR sky130_fd_sc_hd__tapvpwrvgnd_1
X_1937_ _1942_/B _1935_/Y _1936_/Y VGND VGND VPWR VPWR _2545_/D sky130_fd_sc_hd__o21ai_0
XFILLER_21_135 VGND VGND VPWR VPWR sky130_fd_sc_hd__fill_1
X_1799_ _2497_/Q _1798_/C hold343/X VGND VGND VPWR VPWR _1799_/Y sky130_fd_sc_hd__a21oi_1
X_1868_ _1933_/B _1866_/Y _1867_/Y VGND VGND VPWR VPWR _2522_/D sky130_fd_sc_hd__o21ai_0
XFILLER_29_213 VGND VGND VPWR VPWR sky130_fd_sc_hd__decap_8
XFILLER_12_113 VGND VGND VPWR VPWR sky130_fd_sc_hd__fill_2
XFILLER_32_42 VGND VGND VPWR VPWR sky130_fd_sc_hd__decap_4
XTAP_TAPCELL_ROW_7_183 VGND VPWR sky130_fd_sc_hd__tapvpwrvgnd_1
XFILLER_50_219 VGND VGND VPWR VPWR sky130_fd_sc_hd__fill_2
X_1584_ _2625_/Q _2624_/Q _1584_/C VGND VGND VPWR VPWR _1589_/C sky130_fd_sc_hd__and3_1
X_1722_ _1720_/X _1721_/Y _1715_/Y VGND VGND VPWR VPWR _1723_/C sky130_fd_sc_hd__o21ai_0
XPHY_EDGE_ROW_9_Right_9 VGND VGND VPWR VPWR sky130_fd_sc_hd__decap_3
X_1653_ _1657_/D _1650_/Y _1651_/Y _1652_/Y VGND VGND VPWR VPWR _2468_/D sky130_fd_sc_hd__a31oi_1
X_2205_ _2206_/A _2206_/B VGND VGND VPWR VPWR _2222_/B sky130_fd_sc_hd__nand2_1
X_2136_ _2136_/A _2136_/B VGND VGND VPWR VPWR _2136_/Y sky130_fd_sc_hd__nand2_1
X_2067_ _2457_/Q _2399_/Q _2067_/S VGND VGND VPWR VPWR _2399_/D sky130_fd_sc_hd__mux2_1
XTAP_TAPCELL_ROW_70_501 VGND VPWR sky130_fd_sc_hd__tapvpwrvgnd_1
XFILLER_40_263 VGND VGND VPWR VPWR sky130_fd_sc_hd__decap_4
XTAP_TAPCELL_ROW_10_199 VGND VPWR sky130_fd_sc_hd__tapvpwrvgnd_1
XFILLER_4_197 VGND VGND VPWR VPWR sky130_fd_sc_hd__decap_8
XFILLER_23_208 VGND VGND VPWR VPWR sky130_fd_sc_hd__decap_12
XFILLER_31_274 VGND VGND VPWR VPWR sky130_fd_sc_hd__decap_6
X_1705_ _2333_/A _2318_/A _1671_/C _1704_/Y VGND VGND VPWR VPWR _2485_/D sky130_fd_sc_hd__a31oi_1
X_1567_ _1567_/A _1977_/B VGND VGND VPWR VPWR _2617_/D sky130_fd_sc_hd__nor2_1
X_1636_ _1242_/Y _1635_/Y _1638_/S VGND VGND VPWR VPWR _2461_/D sky130_fd_sc_hd__mux2i_1
X_1498_ _2187_/B _2171_/A _2619_/Q _2201_/B VGND VGND VPWR VPWR _1498_/Y sky130_fd_sc_hd__o22ai_1
X_2119_ _2119_/A _2119_/B _2119_/C _2119_/D VGND VGND VPWR VPWR _2122_/A sky130_fd_sc_hd__nand4_1
XTAP_TAPCELL_ROW_1_156 VGND VPWR sky130_fd_sc_hd__tapvpwrvgnd_1
Xfanout78 _2196_/B VGND VGND VPWR VPWR _2136_/A sky130_fd_sc_hd__clkdlybuf4s50_1
Xfanout67 _1974_/S VGND VGND VPWR VPWR _1965_/S sky130_fd_sc_hd__clkdlybuf4s50_1
Xfanout23 _2167_/X VGND VGND VPWR VPWR _2224_/A2 sky130_fd_sc_hd__clkdlybuf4s50_1
Xfanout89 _2042_/B VGND VGND VPWR VPWR _2038_/B sky130_fd_sc_hd__clkdlybuf4s50_1
Xfanout12 _2380_/S VGND VGND VPWR VPWR _1638_/S sky130_fd_sc_hd__clkdlybuf4s50_1
Xfanout45 _1930_/B VGND VGND VPWR VPWR _1942_/B sky130_fd_sc_hd__clkdlybuf4s50_1
XTAP_TAPCELL_ROW_24_269 VGND VPWR sky130_fd_sc_hd__tapvpwrvgnd_1
XFILLER_13_88 VGND VGND VPWR VPWR sky130_fd_sc_hd__fill_1
XFILLER_1_167 VGND VGND VPWR VPWR sky130_fd_sc_hd__fill_1
XTAP_TAPCELL_ROW_15_225 VGND VPWR sky130_fd_sc_hd__tapvpwrvgnd_1
XFILLER_70_61 VGND VGND VPWR VPWR sky130_fd_sc_hd__fill_1
XFILLER_13_241 VGND VGND VPWR VPWR sky130_fd_sc_hd__decap_8
XFILLER_62_7 VGND VGND VPWR VPWR sky130_fd_sc_hd__fill_1
X_2470_ clkload5/A _2470_/D load_slew162/X VGND VGND VPWR VPWR _2470_/Q sky130_fd_sc_hd__dfrtp_1
X_1421_ _1442_/C _1421_/B VGND VGND VPWR VPWR _1421_/X sky130_fd_sc_hd__xor2_1
X_1283_ _2473_/Q _1275_/Y _1282_/X VGND VGND VPWR VPWR _1283_/Y sky130_fd_sc_hd__o21ai_0
XTAP_TAPCELL_ROW_38_339 VGND VPWR sky130_fd_sc_hd__tapvpwrvgnd_1
X_1352_ _2159_/A _2158_/B VGND VGND VPWR VPWR _1352_/Y sky130_fd_sc_hd__nand2_1
Xclkload9 clkload9/A VGND VGND VPWR VPWR clkload9/Y sky130_fd_sc_hd__clkinv_2
X_2599_ clkload2/A _2599_/D fanout156/X VGND VGND VPWR VPWR _2599_/Q sky130_fd_sc_hd__dfrtp_1
X_1619_ _1627_/A _2454_/Q VGND VGND VPWR VPWR _1619_/Y sky130_fd_sc_hd__nand2_1
XTAP_TAPCELL_ROW_20_250 VGND VPWR sky130_fd_sc_hd__tapvpwrvgnd_1
XFILLER_40_64 VGND VGND VPWR VPWR sky130_fd_sc_hd__decap_8
XFILLER_6_237 VGND VGND VPWR VPWR sky130_fd_sc_hd__decap_4
XFILLER_65_50 VGND VGND VPWR VPWR sky130_fd_sc_hd__decap_6
XFILLER_49_51 VGND VGND VPWR VPWR sky130_fd_sc_hd__decap_4
X_1970_ _1969_/B _1968_/Y _1969_/Y VGND VGND VPWR VPWR _1970_/Y sky130_fd_sc_hd__o21ai_0
XFILLER_60_122 VGND VGND VPWR VPWR sky130_fd_sc_hd__decap_6
XFILLER_60_111 VGND VGND VPWR VPWR sky130_fd_sc_hd__fill_1
XFILLER_45_174 VGND VGND VPWR VPWR sky130_fd_sc_hd__decap_12
XTAP_TAPCELL_ROW_43_364 VGND VPWR sky130_fd_sc_hd__tapvpwrvgnd_1
XFILLER_53_3 VGND VGND VPWR VPWR sky130_fd_sc_hd__decap_8
X_2522_ clkload6/A _2522_/D load_slew142/X VGND VGND VPWR VPWR _2522_/Q sky130_fd_sc_hd__dfrtp_1
X_2384_ _1238_/Y _2383_/Y _2384_/S VGND VGND VPWR VPWR _2446_/D sky130_fd_sc_hd__mux2i_1
X_1335_ _1484_/A _2272_/A VGND VGND VPWR VPWR _1339_/C sky130_fd_sc_hd__xor2_1
XFILLER_5_281 VGND VGND VPWR VPWR sky130_fd_sc_hd__decap_8
X_2453_ clkload6/A _2453_/D load_slew144/X VGND VGND VPWR VPWR _2453_/Q sky130_fd_sc_hd__dfrtp_1
X_1404_ _2436_/Q _2273_/A VGND VGND VPWR VPWR _1406_/B sky130_fd_sc_hd__nand2_1
Xinput2 spdif_in VGND VGND VPWR VPWR input2/X sky130_fd_sc_hd__clkdlybuf4s50_1
XTAP_TAPCELL_ROW_66_478 VGND VPWR sky130_fd_sc_hd__tapvpwrvgnd_1
X_1266_ _2198_/B _2185_/B VGND VGND VPWR VPWR _1266_/Y sky130_fd_sc_hd__nand2_1
X_1197_ _2176_/A VGND VGND VPWR VPWR _2212_/B sky130_fd_sc_hd__inv_1
XTAP_TAPCELL_ROW_34_320 VGND VPWR sky130_fd_sc_hd__tapvpwrvgnd_1
XFILLER_59_211 VGND VGND VPWR VPWR sky130_fd_sc_hd__fill_1
XTAP_TAPCELL_ROW_57_434 VGND VPWR sky130_fd_sc_hd__tapvpwrvgnd_1
XFILLER_19_54 VGND VGND VPWR VPWR sky130_fd_sc_hd__fill_2
XFILLER_19_119 VGND VGND VPWR VPWR sky130_fd_sc_hd__fill_1
XFILLER_42_144 VGND VGND VPWR VPWR sky130_fd_sc_hd__fill_1
XFILLER_33_111 VGND VGND VPWR VPWR sky130_fd_sc_hd__fill_1
XFILLER_18_141 VGND VGND VPWR VPWR sky130_fd_sc_hd__decap_6
X_1884_ _2527_/Q _2601_/Q _1884_/S VGND VGND VPWR VPWR _1884_/Y sky130_fd_sc_hd__mux2i_1
X_1953_ _2550_/Q _2576_/Q _1956_/S VGND VGND VPWR VPWR _1953_/Y sky130_fd_sc_hd__mux2i_1
XFILLER_33_133 VGND VGND VPWR VPWR sky130_fd_sc_hd__decap_3
X_2505_ _2607_/CLK _2505_/D fanout178/X VGND VGND VPWR VPWR i2s_sd sky130_fd_sc_hd__dfrtp_1
X_1318_ _1486_/A _2287_/B VGND VGND VPWR VPWR _1340_/C sky130_fd_sc_hd__xor2_1
X_2436_ clkload4/A _2436_/D fanout159/X VGND VGND VPWR VPWR _2436_/Q sky130_fd_sc_hd__dfstp_2
X_2367_ fanout3/X _2364_/Y _2366_/Y _2096_/A _2331_/B VGND VGND VPWR VPWR _2438_/D
+ sky130_fd_sc_hd__o32a_1
X_2298_ _2287_/B _2167_/X _2360_/A VGND VGND VPWR VPWR _2298_/Y sky130_fd_sc_hd__o21ai_0
X_1249_ _2497_/Q VGND VGND VPWR VPWR _1810_/A sky130_fd_sc_hd__inv_1
XFILLER_24_100 VGND VGND VPWR VPWR sky130_fd_sc_hd__fill_2
XFILLER_21_55 VGND VGND VPWR VPWR sky130_fd_sc_hd__fill_1
XFILLER_62_239 VGND VGND VPWR VPWR sky130_fd_sc_hd__fill_2
XFILLER_47_225 VGND VGND VPWR VPWR sky130_fd_sc_hd__fill_1
Xmax_cap42 wire43/X VGND VGND VPWR VPWR _1315_/B sky130_fd_sc_hd__clkdlybuf4s25_1
Xmax_cap20 _1651_/C VGND VGND VPWR VPWR _2052_/B sky130_fd_sc_hd__buf_1
Xmax_cap31 wire32/X VGND VGND VPWR VPWR _1417_/A2 sky130_fd_sc_hd__clkdlybuf4s25_1
XFILLER_30_158 VGND VGND VPWR VPWR sky130_fd_sc_hd__fill_2
XFILLER_7_35 VGND VGND VPWR VPWR sky130_fd_sc_hd__fill_1
X_2221_ _2222_/A _2222_/B _2222_/C VGND VGND VPWR VPWR _2229_/B sky130_fd_sc_hd__a21oi_1
XFILLER_16_3 VGND VGND VPWR VPWR sky130_fd_sc_hd__fill_1
X_2152_ _2481_/Q _2152_/B VGND VGND VPWR VPWR _2152_/Y sky130_fd_sc_hd__nand2_1
X_2083_ _2101_/A _2080_/B _2083_/B1 _2080_/D _2082_/Y VGND VGND VPWR VPWR _2083_/X
+ sky130_fd_sc_hd__o2111a_1
X_1936_ _1936_/A _1942_/B VGND VGND VPWR VPWR _1936_/Y sky130_fd_sc_hd__nand2_1
X_1867_ _1867_/A _1933_/B VGND VGND VPWR VPWR _1867_/Y sky130_fd_sc_hd__nand2_1
XFILLER_21_125 VGND VGND VPWR VPWR sky130_fd_sc_hd__fill_1
XFILLER_21_169 VGND VGND VPWR VPWR sky130_fd_sc_hd__fill_1
X_1798_ _2497_/Q _2498_/Q _1798_/C VGND VGND VPWR VPWR _1805_/D sky130_fd_sc_hd__and3_1
XFILLER_29_225 VGND VGND VPWR VPWR sky130_fd_sc_hd__decap_3
X_2419_ _2592_/CLK _2419_/D _2437_/SET_B VGND VGND VPWR VPWR _2419_/Q sky130_fd_sc_hd__dfrtp_1
XFILLER_44_239 VGND VGND VPWR VPWR sky130_fd_sc_hd__fill_1
XFILLER_12_136 VGND VGND VPWR VPWR sky130_fd_sc_hd__decap_4
XFILLER_8_129 VGND VGND VPWR VPWR sky130_fd_sc_hd__decap_8
XTAP_TAPCELL_ROW_7_184 VGND VPWR sky130_fd_sc_hd__tapvpwrvgnd_1
XFILLER_43_261 VGND VGND VPWR VPWR sky130_fd_sc_hd__decap_6
XPHY_EDGE_ROW_35_Left_106 VGND VGND VPWR VPWR sky130_fd_sc_hd__decap_3
X_1721_ _2447_/Q _2389_/Q _2446_/Q _2388_/Q VGND VGND VPWR VPWR _1721_/Y sky130_fd_sc_hd__o22ai_1
X_1583_ _1603_/A _1585_/B _1583_/C VGND VGND VPWR VPWR _2624_/D sky130_fd_sc_hd__nor3_1
XPHY_EDGE_ROW_44_Left_115 VGND VGND VPWR VPWR sky130_fd_sc_hd__decap_3
X_1652_ _2468_/Q _1657_/D VGND VGND VPWR VPWR _1652_/Y sky130_fd_sc_hd__nor2_1
X_2204_ _2190_/A _2192_/B _2189_/Y VGND VGND VPWR VPWR _2206_/B sky130_fd_sc_hd__o21ai_0
XPHY_EDGE_ROW_53_Left_124 VGND VGND VPWR VPWR sky130_fd_sc_hd__decap_3
X_2135_ _1221_/Y _1454_/X _1565_/Y _2167_/A VGND VGND VPWR VPWR _2136_/B sky130_fd_sc_hd__a211o_1
XFILLER_26_217 VGND VGND VPWR VPWR sky130_fd_sc_hd__decap_12
X_2066_ _2456_/Q _2398_/Q _2067_/S VGND VGND VPWR VPWR _2398_/D sky130_fd_sc_hd__mux2_1
XPHY_EDGE_ROW_62_Left_133 VGND VGND VPWR VPWR sky130_fd_sc_hd__decap_3
X_1919_ _1948_/B _1917_/Y _1918_/Y VGND VGND VPWR VPWR _1919_/Y sky130_fd_sc_hd__o21ai_0
XTAP_TAPCELL_ROW_70_502 VGND VPWR sky130_fd_sc_hd__tapvpwrvgnd_1
XFILLER_40_253 VGND VGND VPWR VPWR sky130_fd_sc_hd__fill_2
Xload_slew8 _2054_/S VGND VGND VPWR VPWR _2074_/S sky130_fd_sc_hd__buf_4
XFILLER_4_176 VGND VGND VPWR VPWR sky130_fd_sc_hd__decap_3
XFILLER_4_132 VGND VGND VPWR VPWR sky130_fd_sc_hd__decap_8
XFILLER_68_72 VGND VGND VPWR VPWR sky130_fd_sc_hd__fill_1
XFILLER_67_117 VGND VGND VPWR VPWR sky130_fd_sc_hd__decap_3
X_1704_ _2318_/A _1671_/C _1466_/B VGND VGND VPWR VPWR _1704_/Y sky130_fd_sc_hd__o21ai_0
X_1497_ _1201_/Y _2617_/Q _2618_/Q VGND VGND VPWR VPWR _1497_/Y sky130_fd_sc_hd__a21oi_1
X_1635_ _2383_/A _2462_/Q VGND VGND VPWR VPWR _1635_/Y sky130_fd_sc_hd__nand2_1
X_1566_ _2470_/Q _1559_/Y _1560_/Y _1557_/A VGND VGND VPWR VPWR _2608_/D sky130_fd_sc_hd__a22o_1
X_2118_ _2465_/Q _2407_/Q _2466_/Q _2408_/Q VGND VGND VPWR VPWR _2130_/B sky130_fd_sc_hd__nor4_1
X_2049_ _1246_/Y _2050_/B _2048_/Y VGND VGND VPWR VPWR _2606_/D sky130_fd_sc_hd__a21oi_1
XTAP_TAPCELL_ROW_49_392 VGND VPWR sky130_fd_sc_hd__tapvpwrvgnd_1
Xfanout79 _1459_/X VGND VGND VPWR VPWR _2196_/B sky130_fd_sc_hd__clkdlybuf4s50_1
Xfanout46 _1924_/B VGND VGND VPWR VPWR _1930_/B sky130_fd_sc_hd__clkdlybuf4s50_1
XFILLER_38_75 VGND VGND VPWR VPWR sky130_fd_sc_hd__fill_2
XFILLER_54_85 VGND VGND VPWR VPWR sky130_fd_sc_hd__decap_8
XTAP_TAPCELL_ROW_15_226 VGND VPWR sky130_fd_sc_hd__tapvpwrvgnd_1
XFILLER_9_268 VGND VGND VPWR VPWR sky130_fd_sc_hd__decap_12
XFILLER_13_253 VGND VGND VPWR VPWR sky130_fd_sc_hd__fill_2
X_1420_ _1442_/C _1421_/B VGND VGND VPWR VPWR _1420_/Y sky130_fd_sc_hd__xnor2_1
X_1351_ _2159_/A _2158_/B VGND VGND VPWR VPWR _1357_/B sky130_fd_sc_hd__nor2_1
X_1282_ _2472_/Q _1282_/B _1282_/C VGND VGND VPWR VPWR _1282_/X sky130_fd_sc_hd__maj3_1
X_1618_ _1232_/Y _1617_/Y _1624_/S VGND VGND VPWR VPWR _2452_/D sky130_fd_sc_hd__mux2i_1
X_1549_ _2414_/Q _2415_/Q _2416_/Q _2417_/Q VGND VGND VPWR VPWR _2108_/A sky130_fd_sc_hd__nor4_1
X_2598_ clkload1/A _2598_/D load_slew152/X VGND VGND VPWR VPWR _2598_/Q sky130_fd_sc_hd__dfrtp_1
XFILLER_54_197 VGND VGND VPWR VPWR sky130_fd_sc_hd__decap_4
XTAP_TAPCELL_ROW_12_207 VGND VPWR sky130_fd_sc_hd__tapvpwrvgnd_1
XTAP_TAPCELL_ROW_20_251 VGND VPWR sky130_fd_sc_hd__tapvpwrvgnd_1
Xhold290 _1981_/X VGND VGND VPWR VPWR _2561_/D sky130_fd_sc_hd__dlygate4sd3_1
XFILLER_1_15 VGND VGND VPWR VPWR sky130_fd_sc_hd__fill_1
XFILLER_45_186 VGND VGND VPWR VPWR sky130_fd_sc_hd__fill_2
XTAP_TAPCELL_ROW_43_365 VGND VPWR sky130_fd_sc_hd__tapvpwrvgnd_1
X_2521_ clkload6/A _2521_/D load_slew142/X VGND VGND VPWR VPWR _2521_/Q sky130_fd_sc_hd__dfrtp_1
X_2383_ _2383_/A _2447_/Q VGND VGND VPWR VPWR _2383_/Y sky130_fd_sc_hd__nand2_1
X_1334_ _1321_/Y _1323_/Y _1333_/Y VGND VGND VPWR VPWR _1334_/Y sky130_fd_sc_hd__o21ai_0
X_1265_ _2411_/Q _2082_/B _1265_/C VGND VGND VPWR VPWR _1651_/B sky130_fd_sc_hd__or3_1
X_2452_ clkload6/A _2452_/D load_slew144/X VGND VGND VPWR VPWR _2452_/Q sky130_fd_sc_hd__dfrtp_1
XPHY_EDGE_ROW_18_Right_18 VGND VGND VPWR VPWR sky130_fd_sc_hd__decap_3
X_1403_ _2272_/A _2287_/B _1442_/C _1402_/Y _1381_/X VGND VGND VPWR VPWR wire32/A
+ sky130_fd_sc_hd__a221oi_1
XTAP_TAPCELL_ROW_66_479 VGND VPWR sky130_fd_sc_hd__tapvpwrvgnd_1
X_1196_ _2230_/B VGND VGND VPWR VPWR _1303_/A sky130_fd_sc_hd__inv_1
XTAP_TAPCELL_ROW_34_321 VGND VPWR sky130_fd_sc_hd__tapvpwrvgnd_1
XPHY_EDGE_ROW_27_Right_27 VGND VGND VPWR VPWR sky130_fd_sc_hd__decap_3
XPHY_EDGE_ROW_36_Right_36 VGND VGND VPWR VPWR sky130_fd_sc_hd__decap_3
XTAP_TAPCELL_ROW_57_435 VGND VPWR sky130_fd_sc_hd__tapvpwrvgnd_1
XFILLER_27_153 VGND VGND VPWR VPWR sky130_fd_sc_hd__decap_4
XPHY_EDGE_ROW_45_Right_45 VGND VGND VPWR VPWR sky130_fd_sc_hd__decap_3
XFILLER_42_189 VGND VGND VPWR VPWR sky130_fd_sc_hd__decap_6
XFILLER_42_156 VGND VGND VPWR VPWR sky130_fd_sc_hd__decap_12
XPHY_EDGE_ROW_54_Right_54 VGND VGND VPWR VPWR sky130_fd_sc_hd__decap_3
XFILLER_51_53 VGND VGND VPWR VPWR sky130_fd_sc_hd__decap_3
XFILLER_65_259 VGND VGND VPWR VPWR sky130_fd_sc_hd__fill_1
XPHY_EDGE_ROW_63_Right_63 VGND VGND VPWR VPWR sky130_fd_sc_hd__decap_3
XFILLER_18_197 VGND VGND VPWR VPWR sky130_fd_sc_hd__decap_4
X_1883_ _1951_/B _1881_/Y _1882_/Y VGND VGND VPWR VPWR _1883_/Y sky130_fd_sc_hd__o21ai_0
X_1952_ _1951_/B _1950_/Y _1951_/Y VGND VGND VPWR VPWR _2550_/D sky130_fd_sc_hd__o21ai_0
XTAP_TAPCELL_ROW_31_302 VGND VPWR sky130_fd_sc_hd__tapvpwrvgnd_1
X_2504_ _2633_/CLK _2504_/D fanout187/A VGND VGND VPWR VPWR _2504_/Q sky130_fd_sc_hd__dfrtp_1
X_2435_ clkload3/A _2435_/D fanout157/A VGND VGND VPWR VPWR _2435_/Q sky130_fd_sc_hd__dfstp_2
X_1248_ _2496_/Q VGND VGND VPWR VPWR _1809_/A sky130_fd_sc_hd__inv_1
XFILLER_56_215 VGND VGND VPWR VPWR sky130_fd_sc_hd__fill_1
X_1317_ _2478_/Q _1311_/X _1322_/B _1690_/A VGND VGND VPWR VPWR _1317_/Y sky130_fd_sc_hd__o22ai_1
X_2297_ _2297_/A _2297_/B VGND VGND VPWR VPWR _2297_/Y sky130_fd_sc_hd__nor2_1
X_2366_ _2333_/A _2286_/S _2365_/Y VGND VGND VPWR VPWR _2366_/Y sky130_fd_sc_hd__a21oi_1
XTAP_TAPCELL_ROW_62_460 VGND VPWR sky130_fd_sc_hd__tapvpwrvgnd_1
XFILLER_47_248 VGND VGND VPWR VPWR sky130_fd_sc_hd__decap_8
XFILLER_70_273 VGND VGND VPWR VPWR sky130_fd_sc_hd__decap_6
XFILLER_62_85 VGND VGND VPWR VPWR sky130_fd_sc_hd__fill_2
X_2220_ _2220_/A _2220_/B VGND VGND VPWR VPWR _2222_/C sky130_fd_sc_hd__xnor2_1
X_2082_ _2082_/A _2082_/B VGND VGND VPWR VPWR _2082_/Y sky130_fd_sc_hd__nand2_1
X_2151_ _1519_/A _2480_/Q _2148_/Y _2152_/B _2150_/Y VGND VGND VPWR VPWR _2151_/Y
+ sky130_fd_sc_hd__o2111ai_1
XFILLER_53_218 VGND VGND VPWR VPWR sky130_fd_sc_hd__decap_6
X_1797_ _1810_/A _1798_/C VGND VGND VPWR VPWR _2497_/D sky130_fd_sc_hd__xnor2_1
X_1866_ _2521_/Q _2595_/Q _1926_/S VGND VGND VPWR VPWR _1866_/Y sky130_fd_sc_hd__mux2i_1
X_1935_ _2544_/Q _2570_/Q _1944_/S VGND VGND VPWR VPWR _1935_/Y sky130_fd_sc_hd__mux2i_1
X_2418_ _2592_/CLK _2418_/D _2437_/SET_B VGND VGND VPWR VPWR _2418_/Q sky130_fd_sc_hd__dfrtp_1
XFILLER_29_237 VGND VGND VPWR VPWR sky130_fd_sc_hd__fill_1
X_2349_ _2349_/A _2349_/B VGND VGND VPWR VPWR _2350_/B sky130_fd_sc_hd__nand2_1
XFILLER_52_273 VGND VGND VPWR VPWR sky130_fd_sc_hd__fill_1
XFILLER_52_240 VGND VGND VPWR VPWR sky130_fd_sc_hd__decap_3
XPHY_EDGE_ROW_0_Right_0 VGND VGND VPWR VPWR sky130_fd_sc_hd__decap_3
XFILLER_12_148 VGND VGND VPWR VPWR sky130_fd_sc_hd__decap_4
XFILLER_20_170 VGND VGND VPWR VPWR sky130_fd_sc_hd__decap_4
XTAP_TAPCELL_ROW_7_185 VGND VPWR sky130_fd_sc_hd__tapvpwrvgnd_1
X_1720_ _1716_/Y _2128_/A _2128_/B _1719_/Y VGND VGND VPWR VPWR _1720_/X sky130_fd_sc_hd__o31a_1
XFILLER_7_141 VGND VGND VPWR VPWR sky130_fd_sc_hd__fill_1
X_1651_ _2468_/Q _1651_/B _1651_/C VGND VGND VPWR VPWR _1651_/Y sky130_fd_sc_hd__nand3_1
X_1582_ _2624_/Q _1584_/C VGND VGND VPWR VPWR _1583_/C sky130_fd_sc_hd__nor2_1
X_2203_ _2203_/A _2203_/B VGND VGND VPWR VPWR _2206_/A sky130_fd_sc_hd__xnor2_1
X_2065_ _2455_/Q _2397_/Q _2067_/S VGND VGND VPWR VPWR _2397_/D sky130_fd_sc_hd__mux2_1
XFILLER_19_270 VGND VGND VPWR VPWR sky130_fd_sc_hd__fill_2
XFILLER_19_281 VGND VGND VPWR VPWR sky130_fd_sc_hd__decap_8
X_2134_ _1657_/C _2133_/Y _2132_/Y VGND VGND VPWR VPWR _2422_/D sky130_fd_sc_hd__a21oi_1
XFILLER_26_229 VGND VGND VPWR VPWR sky130_fd_sc_hd__decap_4
XFILLER_34_251 VGND VGND VPWR VPWR sky130_fd_sc_hd__fill_1
X_1918_ _1918_/A _1948_/B VGND VGND VPWR VPWR _1918_/Y sky130_fd_sc_hd__nand2_1
X_1849_ _1849_/A _1945_/B VGND VGND VPWR VPWR _1849_/Y sky130_fd_sc_hd__nand2_1
XTAP_TAPCELL_ROW_70_503 VGND VPWR sky130_fd_sc_hd__tapvpwrvgnd_1
XFILLER_43_32 VGND VGND VPWR VPWR sky130_fd_sc_hd__decap_4
XFILLER_43_65 VGND VGND VPWR VPWR sky130_fd_sc_hd__fill_2
XFILLER_4_188 VGND VGND VPWR VPWR sky130_fd_sc_hd__fill_1
XFILLER_16_251 VGND VGND VPWR VPWR sky130_fd_sc_hd__fill_1
X_1634_ _1224_/Y _1633_/Y _1638_/S VGND VGND VPWR VPWR _2460_/D sky130_fd_sc_hd__mux2i_1
X_1703_ _1672_/C _1702_/Y _2327_/B VGND VGND VPWR VPWR _2484_/D sky130_fd_sc_hd__a21oi_1
Xclkbuf_leaf_11_clk clkbuf_leaf_9_clk/A VGND VGND VPWR VPWR clkload5/A sky130_fd_sc_hd__clkbuf_16
X_1496_ _1496_/A _1570_/B _1496_/C VGND VGND VPWR VPWR _1500_/A sky130_fd_sc_hd__nor3_1
XFILLER_58_118 VGND VGND VPWR VPWR sky130_fd_sc_hd__decap_6
X_1565_ _2082_/A _2470_/Q VGND VGND VPWR VPWR _1565_/Y sky130_fd_sc_hd__nand2_1
XPHY_EDGE_ROW_18_Left_89 VGND VGND VPWR VPWR sky130_fd_sc_hd__decap_3
X_2048_ _2048_/A _2050_/B VGND VGND VPWR VPWR _2048_/Y sky130_fd_sc_hd__nor2_1
XTAP_TAPCELL_ROW_49_393 VGND VPWR sky130_fd_sc_hd__tapvpwrvgnd_1
X_2117_ hold353/X _2114_/X _2101_/Y VGND VGND VPWR VPWR _2420_/D sky130_fd_sc_hd__a21o_1
Xfanout69 _1947_/S VGND VGND VPWR VPWR _1974_/S sky130_fd_sc_hd__clkdlybuf4s50_1
Xfanout47 _1948_/B VGND VGND VPWR VPWR _1945_/B sky130_fd_sc_hd__clkdlybuf4s50_1
Xfanout14 _1606_/X VGND VGND VPWR VPWR _2380_/S sky130_fd_sc_hd__clkdlybuf4s50_1
XFILLER_13_57 VGND VGND VPWR VPWR sky130_fd_sc_hd__decap_6
Xfanout25 _2286_/S VGND VGND VPWR VPWR _2359_/S sky130_fd_sc_hd__clkdlybuf4s50_1
XFILLER_22_232 VGND VGND VPWR VPWR sky130_fd_sc_hd__fill_2
XFILLER_57_151 VGND VGND VPWR VPWR sky130_fd_sc_hd__decap_4
XFILLER_38_98 VGND VGND VPWR VPWR sky130_fd_sc_hd__decap_6
XFILLER_1_169 VGND VGND VPWR VPWR sky130_fd_sc_hd__decap_4
XFILLER_54_42 VGND VGND VPWR VPWR sky130_fd_sc_hd__decap_3
XFILLER_70_41 VGND VGND VPWR VPWR sky130_fd_sc_hd__decap_4
X_1281_ _1389_/B _1432_/B _1431_/B VGND VGND VPWR VPWR _1282_/C sky130_fd_sc_hd__mux2i_1
X_1350_ _2483_/Q _1347_/Y _1349_/Y VGND VGND VPWR VPWR _1350_/X sky130_fd_sc_hd__a21o_1
XFILLER_63_165 VGND VGND VPWR VPWR sky130_fd_sc_hd__decap_3
Xclkbuf_leaf_0_clk clkbuf_leaf_9_clk/A VGND VGND VPWR VPWR clkload1/A sky130_fd_sc_hd__clkbuf_16
X_1617_ _1627_/A _2453_/Q VGND VGND VPWR VPWR _1617_/Y sky130_fd_sc_hd__nand2_1
X_2597_ clkload1/A _2597_/D load_slew150/X VGND VGND VPWR VPWR _2597_/Q sky130_fd_sc_hd__dfrtp_1
X_1479_ _2241_/B _1507_/A VGND VGND VPWR VPWR _1512_/B sky130_fd_sc_hd__nand2_1
X_1548_ _2414_/Q _2415_/Q _2416_/Q VGND VGND VPWR VPWR _2105_/A sky130_fd_sc_hd__nor3_1
XTAP_TAPCELL_ROW_12_208 VGND VPWR sky130_fd_sc_hd__tapvpwrvgnd_1
XFILLER_10_235 VGND VGND VPWR VPWR sky130_fd_sc_hd__fill_2
Xhold291 _2518_/Q VGND VGND VPWR VPWR _1855_/A sky130_fd_sc_hd__dlygate4sd3_1
Xhold280 _2567_/Q VGND VGND VPWR VPWR hold280/X sky130_fd_sc_hd__dlygate4sd3_1
XTAP_TAPCELL_ROW_43_366 VGND VPWR sky130_fd_sc_hd__tapvpwrvgnd_1
X_1402_ _1421_/B _1443_/A VGND VGND VPWR VPWR _1402_/Y sky130_fd_sc_hd__nor2_1
XFILLER_5_261 VGND VGND VPWR VPWR sky130_fd_sc_hd__decap_12
X_2520_ clkload6/A _2520_/D load_slew142/X VGND VGND VPWR VPWR _2520_/Q sky130_fd_sc_hd__dfrtp_1
X_2451_ clkload6/A _2451_/D load_slew147/X VGND VGND VPWR VPWR _2451_/Q sky130_fd_sc_hd__dfrtp_1
X_2382_ _1239_/Y _2381_/Y _2384_/S VGND VGND VPWR VPWR _2445_/D sky130_fd_sc_hd__mux2i_1
XFILLER_39_3 VGND VGND VPWR VPWR sky130_fd_sc_hd__decap_12
X_1333_ _1692_/A _1321_/B _1332_/Y VGND VGND VPWR VPWR _1333_/Y sky130_fd_sc_hd__a21oi_1
X_1264_ _1264_/A _1265_/C VGND VGND VPWR VPWR _2077_/B sky130_fd_sc_hd__nor2_1
XFILLER_51_113 VGND VGND VPWR VPWR sky130_fd_sc_hd__decap_3
X_1195_ _2242_/B VGND VGND VPWR VPWR _2241_/B sky130_fd_sc_hd__inv_1
XFILLER_36_187 VGND VGND VPWR VPWR sky130_fd_sc_hd__decap_3
XFILLER_59_202 VGND VGND VPWR VPWR sky130_fd_sc_hd__decap_4
XTAP_TAPCELL_ROW_57_436 VGND VPWR sky130_fd_sc_hd__tapvpwrvgnd_1
XFILLER_27_110 VGND VGND VPWR VPWR sky130_fd_sc_hd__fill_2
XFILLER_51_32 VGND VGND VPWR VPWR sky130_fd_sc_hd__fill_1
XFILLER_50_190 VGND VGND VPWR VPWR sky130_fd_sc_hd__decap_6
XFILLER_42_168 VGND VGND VPWR VPWR sky130_fd_sc_hd__decap_12
XTAP_TAPCELL_ROW_40_347 VGND VPWR sky130_fd_sc_hd__tapvpwrvgnd_1
XFILLER_27_198 VGND VGND VPWR VPWR sky130_fd_sc_hd__fill_1
XFILLER_65_238 VGND VGND VPWR VPWR sky130_fd_sc_hd__decap_6
XFILLER_65_216 VGND VGND VPWR VPWR sky130_fd_sc_hd__fill_1
XFILLER_2_253 VGND VGND VPWR VPWR sky130_fd_sc_hd__fill_2
XFILLER_41_190 VGND VGND VPWR VPWR sky130_fd_sc_hd__decap_6
X_1882_ _1882_/A _1951_/B VGND VGND VPWR VPWR _1882_/Y sky130_fd_sc_hd__nand2_1
X_1951_ _1951_/A _1951_/B VGND VGND VPWR VPWR _1951_/Y sky130_fd_sc_hd__nand2_1
XTAP_TAPCELL_ROW_31_303 VGND VPWR sky130_fd_sc_hd__tapvpwrvgnd_1
X_2503_ _2634_/CLK _2503_/D load_slew175/X VGND VGND VPWR VPWR pwm_out sky130_fd_sc_hd__dfrtp_1
X_2434_ clkload4/A _2434_/D fanout159/X VGND VGND VPWR VPWR _2434_/Q sky130_fd_sc_hd__dfstp_2
X_2365_ _2331_/B _2359_/S _2365_/B1 VGND VGND VPWR VPWR _2365_/Y sky130_fd_sc_hd__o21ai_0
X_1247_ _2466_/Q VGND VGND VPWR VPWR _1247_/Y sky130_fd_sc_hd__inv_1
XTAP_TAPCELL_ROW_54_417 VGND VPWR sky130_fd_sc_hd__tapvpwrvgnd_1
X_1316_ _1340_/A wire43/X VGND VGND VPWR VPWR _1322_/B sky130_fd_sc_hd__xnor2_1
X_2296_ _2296_/A _2296_/B VGND VGND VPWR VPWR _2297_/B sky130_fd_sc_hd__xnor2_1
XTAP_TAPCELL_ROW_62_461 VGND VPWR sky130_fd_sc_hd__tapvpwrvgnd_1
XFILLER_21_57 VGND VGND VPWR VPWR sky130_fd_sc_hd__decap_12
Xmax_cap33 _2264_/B VGND VGND VPWR VPWR _2281_/A2 sky130_fd_sc_hd__clkdlybuf4s25_1
XPHY_EDGE_ROW_6_Left_77 VGND VGND VPWR VPWR sky130_fd_sc_hd__decap_3
XFILLER_15_113 VGND VGND VPWR VPWR sky130_fd_sc_hd__fill_1
XFILLER_62_75 VGND VGND VPWR VPWR sky130_fd_sc_hd__fill_1
XFILLER_15_179 VGND VGND VPWR VPWR sky130_fd_sc_hd__fill_1
XFILLER_38_227 VGND VGND VPWR VPWR sky130_fd_sc_hd__fill_2
XFILLER_38_205 VGND VGND VPWR VPWR sky130_fd_sc_hd__decap_3
X_2081_ _1219_/Y _2080_/Y _2079_/Y VGND VGND VPWR VPWR _2409_/D sky130_fd_sc_hd__a21boi_0
X_2150_ _2305_/B _2481_/Q VGND VGND VPWR VPWR _2150_/Y sky130_fd_sc_hd__xnor2_1
XFILLER_46_271 VGND VGND VPWR VPWR sky130_fd_sc_hd__fill_1
X_1934_ _1933_/B _1932_/Y _1933_/Y VGND VGND VPWR VPWR _1934_/Y sky130_fd_sc_hd__o21ai_0
X_1796_ _1798_/C _1796_/B VGND VGND VPWR VPWR _2496_/D sky130_fd_sc_hd__nor2_1
X_1865_ _1933_/B _1863_/Y _1864_/Y VGND VGND VPWR VPWR _2521_/D sky130_fd_sc_hd__o21ai_0
X_2348_ _2348_/A _2348_/B VGND VGND VPWR VPWR _2350_/A sky130_fd_sc_hd__nand2_1
X_2417_ clkload4/A _2417_/D _2437_/SET_B VGND VGND VPWR VPWR _2417_/Q sky130_fd_sc_hd__dfrtp_1
XFILLER_37_271 VGND VGND VPWR VPWR sky130_fd_sc_hd__decap_8
X_2279_ _2279_/A _2279_/B VGND VGND VPWR VPWR _2282_/A sky130_fd_sc_hd__xnor2_1
XFILLER_16_24 VGND VGND VPWR VPWR sky130_fd_sc_hd__decap_4
XFILLER_16_46 VGND VGND VPWR VPWR sky130_fd_sc_hd__fill_1
XFILLER_32_56 VGND VGND VPWR VPWR sky130_fd_sc_hd__decap_3
XFILLER_32_23 VGND VGND VPWR VPWR sky130_fd_sc_hd__decap_4
XFILLER_35_208 VGND VGND VPWR VPWR sky130_fd_sc_hd__fill_1
XTAP_TAPCELL_ROW_7_186 VGND VPWR sky130_fd_sc_hd__tapvpwrvgnd_1
XFILLER_43_274 VGND VGND VPWR VPWR sky130_fd_sc_hd__decap_6
X_1581_ _2624_/Q _1584_/C VGND VGND VPWR VPWR _1585_/B sky130_fd_sc_hd__and2_0
X_1650_ _1657_/C _1650_/B VGND VGND VPWR VPWR _1650_/Y sky130_fd_sc_hd__nand2_1
X_2202_ _2203_/B _2203_/A VGND VGND VPWR VPWR _2222_/A sky130_fd_sc_hd__nand2b_1
XFILLER_21_3 VGND VGND VPWR VPWR sky130_fd_sc_hd__decap_8
X_2064_ _2454_/Q _2396_/Q _2067_/S VGND VGND VPWR VPWR _2396_/D sky130_fd_sc_hd__mux2_1
X_2133_ locked _1255_/Y _1561_/B _2375_/B VGND VGND VPWR VPWR _2133_/Y sky130_fd_sc_hd__a211oi_1
X_1917_ _2538_/Q _2564_/Q _1917_/S VGND VGND VPWR VPWR _1917_/Y sky130_fd_sc_hd__mux2i_1
X_1779_ _1999_/S _1777_/Y _1778_/Y VGND VGND VPWR VPWR _2491_/D sky130_fd_sc_hd__a21oi_1
X_1848_ _2515_/Q _2589_/Q _1932_/S VGND VGND VPWR VPWR _1848_/Y sky130_fd_sc_hd__mux2i_1
XTAP_TAPCELL_ROW_4_167 VGND VPWR sky130_fd_sc_hd__tapvpwrvgnd_1
XFILLER_17_219 VGND VGND VPWR VPWR sky130_fd_sc_hd__decap_4
XTAP_TAPCELL_ROW_70_504 VGND VPWR sky130_fd_sc_hd__tapvpwrvgnd_1
XFILLER_40_288 VGND VGND VPWR VPWR sky130_fd_sc_hd__fill_1
XFILLER_68_85 VGND VGND VPWR VPWR sky130_fd_sc_hd__fill_2
XFILLER_4_27 VGND VGND VPWR VPWR sky130_fd_sc_hd__fill_1
XPHY_EDGE_ROW_9_Left_80 VGND VGND VPWR VPWR sky130_fd_sc_hd__decap_3
XTAP_TAPCELL_ROW_26_280 VGND VPWR sky130_fd_sc_hd__tapvpwrvgnd_1
XFILLER_69_3 VGND VGND VPWR VPWR sky130_fd_sc_hd__decap_6
X_1633_ _2383_/A _2461_/Q VGND VGND VPWR VPWR _1633_/Y sky130_fd_sc_hd__nand2_1
X_1702_ _2307_/A _1702_/B VGND VGND VPWR VPWR _1702_/Y sky130_fd_sc_hd__xnor2_1
X_1564_ hold362/X _1455_/B _1543_/B _1542_/Y _2609_/Q VGND VGND VPWR VPWR _2609_/D
+ sky130_fd_sc_hd__a32o_1
X_1495_ _2201_/B _1495_/B VGND VGND VPWR VPWR _1496_/C sky130_fd_sc_hd__nor2_1
X_2047_ _1245_/Y _2050_/B _2046_/Y VGND VGND VPWR VPWR _2605_/D sky130_fd_sc_hd__a21oi_1
XTAP_TAPCELL_ROW_49_394 VGND VPWR sky130_fd_sc_hd__tapvpwrvgnd_1
Xfanout26 _2286_/S VGND VGND VPWR VPWR _2255_/B sky130_fd_sc_hd__clkdlybuf4s50_1
X_2116_ _2114_/X _2115_/Y _2101_/Y VGND VGND VPWR VPWR _2419_/D sky130_fd_sc_hd__a21oi_1
Xfanout48 _1924_/B VGND VGND VPWR VPWR _1948_/B sky130_fd_sc_hd__clkdlybuf4s50_1
XFILLER_22_244 VGND VGND VPWR VPWR sky130_fd_sc_hd__decap_4
XFILLER_57_163 VGND VGND VPWR VPWR sky130_fd_sc_hd__fill_2
XFILLER_54_65 VGND VGND VPWR VPWR sky130_fd_sc_hd__decap_3
XFILLER_9_215 VGND VGND VPWR VPWR sky130_fd_sc_hd__fill_2
X_1280_ _2185_/B _2423_/Q VGND VGND VPWR VPWR _1432_/B sky130_fd_sc_hd__xnor2_1
XFILLER_0_181 VGND VGND VPWR VPWR sky130_fd_sc_hd__decap_12
XFILLER_63_111 VGND VGND VPWR VPWR sky130_fd_sc_hd__fill_1
XFILLER_48_174 VGND VGND VPWR VPWR sky130_fd_sc_hd__decap_8
X_2596_ clkload6/A _2596_/D load_slew142/X VGND VGND VPWR VPWR _2596_/Q sky130_fd_sc_hd__dfrtp_1
X_1616_ _1233_/Y _1615_/Y _1624_/S VGND VGND VPWR VPWR _2451_/D sky130_fd_sc_hd__mux2i_1
X_1547_ _1454_/X _1466_/B hold362/X VGND VGND VPWR VPWR _1563_/A sky130_fd_sc_hd__o21ai_0
X_1478_ _2201_/A _1502_/B VGND VGND VPWR VPWR _1507_/A sky130_fd_sc_hd__nor2_1
XPHY_EDGE_ROW_59_Left_130 VGND VGND VPWR VPWR sky130_fd_sc_hd__decap_3
XTAP_TAPCELL_ROW_12_209 VGND VPWR sky130_fd_sc_hd__tapvpwrvgnd_1
XFILLER_40_45 VGND VGND VPWR VPWR sky130_fd_sc_hd__decap_12
XFILLER_40_34 VGND VGND VPWR VPWR sky130_fd_sc_hd__fill_1
XFILLER_49_10 VGND VGND VPWR VPWR sky130_fd_sc_hd__fill_1
Xhold292 _2575_/Q VGND VGND VPWR VPWR hold292/X sky130_fd_sc_hd__dlygate4sd3_1
Xhold270 _1986_/X VGND VGND VPWR VPWR _2566_/D sky130_fd_sc_hd__dlygate4sd3_1
Xhold281 _2574_/Q VGND VGND VPWR VPWR hold281/X sky130_fd_sc_hd__dlygate4sd3_1
XFILLER_65_86 VGND VGND VPWR VPWR sky130_fd_sc_hd__fill_1
XFILLER_45_166 VGND VGND VPWR VPWR sky130_fd_sc_hd__fill_2
XFILLER_45_144 VGND VGND VPWR VPWR sky130_fd_sc_hd__fill_2
XFILLER_45_111 VGND VGND VPWR VPWR sky130_fd_sc_hd__fill_1
X_2381_ _2383_/A _2446_/Q VGND VGND VPWR VPWR _2381_/Y sky130_fd_sc_hd__nand2_1
X_1401_ _2272_/A _2287_/B VGND VGND VPWR VPWR _1443_/A sky130_fd_sc_hd__xnor2_1
XFILLER_5_273 VGND VGND VPWR VPWR sky130_fd_sc_hd__decap_6
X_2450_ _2592_/CLK _2450_/D fanout148/X VGND VGND VPWR VPWR _2450_/Q sky130_fd_sc_hd__dfrtp_1
X_1194_ _2255_/A VGND VGND VPWR VPWR _1512_/A sky130_fd_sc_hd__inv_1
X_1332_ _2481_/Q _1332_/B VGND VGND VPWR VPWR _1332_/Y sky130_fd_sc_hd__nor2_1
X_1263_ _2412_/Q _2413_/Q VGND VGND VPWR VPWR _1265_/C sky130_fd_sc_hd__nand2_1
XFILLER_51_169 VGND VGND VPWR VPWR sky130_fd_sc_hd__decap_12
XFILLER_10_26 VGND VGND VPWR VPWR sky130_fd_sc_hd__fill_2
X_2579_ _2634_/CLK _2579_/D load_slew177/X VGND VGND VPWR VPWR _2579_/Q sky130_fd_sc_hd__dfrtp_1
XFILLER_19_46 VGND VGND VPWR VPWR sky130_fd_sc_hd__decap_8
XFILLER_35_45 VGND VGND VPWR VPWR sky130_fd_sc_hd__decap_3
XFILLER_19_57 VGND VGND VPWR VPWR sky130_fd_sc_hd__decap_12
XTAP_TAPCELL_ROW_40_348 VGND VPWR sky130_fd_sc_hd__tapvpwrvgnd_1
XFILLER_2_276 VGND VGND VPWR VPWR sky130_fd_sc_hd__decap_12
XTAP_TAPCELL_ROW_31_304 VGND VPWR sky130_fd_sc_hd__tapvpwrvgnd_1
X_1950_ _2549_/Q _2575_/Q _1956_/S VGND VGND VPWR VPWR _1950_/Y sky130_fd_sc_hd__mux2i_1
X_2502_ _2634_/CLK _2502_/D load_slew175/X VGND VGND VPWR VPWR _2502_/Q sky130_fd_sc_hd__dfrtp_1
X_1881_ _2526_/Q _2600_/Q _1884_/S VGND VGND VPWR VPWR _1881_/Y sky130_fd_sc_hd__mux2i_1
XFILLER_51_3 VGND VGND VPWR VPWR sky130_fd_sc_hd__decap_4
X_1315_ _1340_/A _1315_/B VGND VGND VPWR VPWR _1315_/Y sky130_fd_sc_hd__nand2_1
X_2433_ clkload4/A _2433_/D fanout159/X VGND VGND VPWR VPWR _2433_/Q sky130_fd_sc_hd__dfstp_2
X_2364_ _2330_/B _2297_/A _2362_/Y _2363_/Y _1557_/A VGND VGND VPWR VPWR _2364_/Y
+ sky130_fd_sc_hd__a221oi_1
XPHY_EDGE_ROW_22_Left_93 VGND VGND VPWR VPWR sky130_fd_sc_hd__decap_3
XFILLER_64_250 VGND VGND VPWR VPWR sky130_fd_sc_hd__fill_2
X_1246_ _2465_/Q VGND VGND VPWR VPWR _1246_/Y sky130_fd_sc_hd__inv_1
XTAP_TAPCELL_ROW_54_418 VGND VPWR sky130_fd_sc_hd__tapvpwrvgnd_1
X_2295_ _2295_/A _2295_/B VGND VGND VPWR VPWR _2296_/B sky130_fd_sc_hd__nor2_1
XFILLER_32_191 VGND VGND VPWR VPWR sky130_fd_sc_hd__decap_4
XFILLER_21_47 VGND VGND VPWR VPWR sky130_fd_sc_hd__decap_8
XFILLER_21_69 VGND VGND VPWR VPWR sky130_fd_sc_hd__fill_1
XFILLER_47_239 VGND VGND VPWR VPWR sky130_fd_sc_hd__fill_2
XFILLER_47_217 VGND VGND VPWR VPWR sky130_fd_sc_hd__decap_6
XFILLER_70_253 VGND VGND VPWR VPWR sky130_fd_sc_hd__decap_4
XFILLER_70_242 VGND VGND VPWR VPWR sky130_fd_sc_hd__fill_2
Xmax_cap56 _1834_/Y VGND VGND VPWR VPWR fanout49/A sky130_fd_sc_hd__buf_1
Xmax_cap34 _2249_/Y VGND VGND VPWR VPWR _2264_/B sky130_fd_sc_hd__clkdlybuf4s25_1
XFILLER_62_65 VGND VGND VPWR VPWR sky130_fd_sc_hd__fill_2
XFILLER_23_191 VGND VGND VPWR VPWR sky130_fd_sc_hd__decap_12
XFILLER_23_7 VGND VGND VPWR VPWR sky130_fd_sc_hd__fill_1
XFILLER_46_261 VGND VGND VPWR VPWR sky130_fd_sc_hd__decap_3
X_2080_ _2082_/A _2080_/B _2080_/C _2080_/D VGND VGND VPWR VPWR _2080_/Y sky130_fd_sc_hd__nand4_1
X_1933_ _1933_/A _1933_/B VGND VGND VPWR VPWR _1933_/Y sky130_fd_sc_hd__nand2_1
X_1795_ _2495_/Q _2634_/Q hold347/X VGND VGND VPWR VPWR _1795_/Y sky130_fd_sc_hd__a21oi_1
X_1864_ _1864_/A _1933_/B VGND VGND VPWR VPWR _1864_/Y sky130_fd_sc_hd__nand2_1
X_2278_ _2279_/A _2279_/B VGND VGND VPWR VPWR _2295_/A sky130_fd_sc_hd__and2_0
X_2347_ _2346_/B _2346_/C _2351_/A VGND VGND VPWR VPWR _2348_/B sky130_fd_sc_hd__a21o_1
X_2416_ clkload4/A _2416_/D _2437_/SET_B VGND VGND VPWR VPWR _2416_/Q sky130_fd_sc_hd__dfrtp_1
XFILLER_52_253 VGND VGND VPWR VPWR sky130_fd_sc_hd__decap_6
X_1229_ _2455_/Q VGND VGND VPWR VPWR _1229_/Y sky130_fd_sc_hd__inv_1
XFILLER_32_46 VGND VGND VPWR VPWR sky130_fd_sc_hd__fill_1
XFILLER_20_150 VGND VGND VPWR VPWR sky130_fd_sc_hd__decap_8
XFILLER_57_54 VGND VGND VPWR VPWR sky130_fd_sc_hd__fill_2
X_1580_ _1977_/B _1584_/C _1580_/C VGND VGND VPWR VPWR _2623_/D sky130_fd_sc_hd__nor3_1
XFILLER_7_110 VGND VGND VPWR VPWR sky130_fd_sc_hd__fill_2
XFILLER_11_161 VGND VGND VPWR VPWR sky130_fd_sc_hd__decap_6
X_2201_ _2201_/A _2201_/B _2201_/C VGND VGND VPWR VPWR _2203_/B sky130_fd_sc_hd__maj3_1
X_2132_ _2077_/B _1657_/D locked VGND VGND VPWR VPWR _2132_/Y sky130_fd_sc_hd__a21oi_1
XFILLER_34_253 VGND VGND VPWR VPWR sky130_fd_sc_hd__decap_12
X_2063_ _2453_/Q hold369/X _2067_/S VGND VGND VPWR VPWR _2395_/D sky130_fd_sc_hd__mux2_1
X_1847_ _1945_/B _1845_/Y _1846_/Y VGND VGND VPWR VPWR _2515_/D sky130_fd_sc_hd__o21ai_0
X_1916_ _1948_/B _1914_/Y _1915_/Y VGND VGND VPWR VPWR _2538_/D sky130_fd_sc_hd__o21ai_0
X_1778_ _1778_/A _1999_/S VGND VGND VPWR VPWR _1778_/Y sky130_fd_sc_hd__nor2_1
XPHY_EDGE_ROW_31_Left_102 VGND VGND VPWR VPWR sky130_fd_sc_hd__decap_3
XPHY_EDGE_ROW_40_Left_111 VGND VGND VPWR VPWR sky130_fd_sc_hd__decap_3
XTAP_TAPCELL_ROW_4_168 VGND VPWR sky130_fd_sc_hd__tapvpwrvgnd_1
XFILLER_17_209 VGND VGND VPWR VPWR sky130_fd_sc_hd__decap_3
XFILLER_27_57 VGND VGND VPWR VPWR sky130_fd_sc_hd__fill_2
XTAP_TAPCELL_ROW_70_505 VGND VPWR sky130_fd_sc_hd__tapvpwrvgnd_1
XFILLER_40_267 VGND VGND VPWR VPWR sky130_fd_sc_hd__fill_1
XFILLER_40_245 VGND VGND VPWR VPWR sky130_fd_sc_hd__fill_1
XFILLER_4_102 VGND VGND VPWR VPWR sky130_fd_sc_hd__decap_4
XFILLER_67_109 VGND VGND VPWR VPWR sky130_fd_sc_hd__decap_3
XFILLER_4_168 VGND VGND VPWR VPWR sky130_fd_sc_hd__decap_8
XFILLER_16_253 VGND VGND VPWR VPWR sky130_fd_sc_hd__decap_4
XTAP_TAPCELL_ROW_18_237 VGND VPWR sky130_fd_sc_hd__tapvpwrvgnd_1
XFILLER_31_256 VGND VGND VPWR VPWR sky130_fd_sc_hd__decap_3
XFILLER_31_223 VGND VGND VPWR VPWR sky130_fd_sc_hd__fill_1
X_1701_ _1672_/C _1700_/Y _2327_/B VGND VGND VPWR VPWR _2483_/D sky130_fd_sc_hd__a21oi_1
XTAP_TAPCELL_ROW_26_281 VGND VPWR sky130_fd_sc_hd__tapvpwrvgnd_1
X_1494_ _2618_/Q _2617_/Q _2619_/Q VGND VGND VPWR VPWR _1570_/B sky130_fd_sc_hd__a21oi_1
X_1632_ _1225_/Y _1631_/Y _1638_/S VGND VGND VPWR VPWR _2459_/D sky130_fd_sc_hd__mux2i_1
X_1563_ _1563_/A _1563_/B _1563_/C VGND VGND VPWR VPWR _2610_/D sky130_fd_sc_hd__nand3_1
X_2115_ _2114_/B _2114_/C wire16/X _2419_/Q VGND VGND VPWR VPWR _2115_/Y sky130_fd_sc_hd__o31ai_1
XFILLER_66_197 VGND VGND VPWR VPWR sky130_fd_sc_hd__fill_2
X_2046_ _2046_/A _2050_/B VGND VGND VPWR VPWR _2046_/Y sky130_fd_sc_hd__nor2_1
XTAP_TAPCELL_ROW_49_395 VGND VPWR sky130_fd_sc_hd__tapvpwrvgnd_1
Xfanout38 _1474_/Y VGND VGND VPWR VPWR _1523_/A sky130_fd_sc_hd__clkdlybuf4s50_1
Xfanout49 fanout49/A VGND VGND VPWR VPWR _1924_/B sky130_fd_sc_hd__clkdlybuf4s50_1
Xfanout27 _2164_/Y VGND VGND VPWR VPWR _2286_/S sky130_fd_sc_hd__clkdlybuf4s50_1
XFILLER_22_223 VGND VGND VPWR VPWR sky130_fd_sc_hd__fill_2
XFILLER_22_256 VGND VGND VPWR VPWR sky130_fd_sc_hd__fill_1
XFILLER_70_76 VGND VGND VPWR VPWR sky130_fd_sc_hd__decap_8
XFILLER_70_65 VGND VGND VPWR VPWR sky130_fd_sc_hd__decap_4
XFILLER_9_249 VGND VGND VPWR VPWR sky130_fd_sc_hd__decap_12
XFILLER_13_223 VGND VGND VPWR VPWR sky130_fd_sc_hd__fill_1
XFILLER_13_278 VGND VGND VPWR VPWR sky130_fd_sc_hd__fill_2
XTAP_TAPCELL_ROW_23_262 VGND VPWR sky130_fd_sc_hd__tapvpwrvgnd_1
XFILLER_0_193 VGND VGND VPWR VPWR sky130_fd_sc_hd__decap_3
X_1477_ _1477_/A _1477_/B VGND VGND VPWR VPWR _1502_/B sky130_fd_sc_hd__nand2_1
X_2595_ clkload6/A _2595_/D load_slew142/X VGND VGND VPWR VPWR _2595_/Q sky130_fd_sc_hd__dfrtp_1
X_1615_ _1627_/A _2452_/Q VGND VGND VPWR VPWR _1615_/Y sky130_fd_sc_hd__nand2_1
X_1546_ _2077_/B _2098_/D _1540_/X _1545_/Y VGND VGND VPWR VPWR _2611_/D sky130_fd_sc_hd__o31ai_1
XFILLER_54_101 VGND VGND VPWR VPWR sky130_fd_sc_hd__decap_6
XFILLER_39_131 VGND VGND VPWR VPWR sky130_fd_sc_hd__fill_1
XTAP_TAPCELL_ROW_37_332 VGND VPWR sky130_fd_sc_hd__tapvpwrvgnd_1
X_2029_ _1229_/Y _2028_/B _2028_/Y VGND VGND VPWR VPWR _2596_/D sky130_fd_sc_hd__a21oi_1
Xhold271 _2578_/Q VGND VGND VPWR VPWR hold271/X sky130_fd_sc_hd__dlygate4sd3_1
Xhold260 _1997_/X VGND VGND VPWR VPWR _2577_/D sky130_fd_sc_hd__dlygate4sd3_1
XFILLER_40_57 VGND VGND VPWR VPWR sky130_fd_sc_hd__decap_4
Xhold282 _2558_/Q VGND VGND VPWR VPWR _1975_/A sky130_fd_sc_hd__dlygate4sd3_1
XFILLER_49_55 VGND VGND VPWR VPWR sky130_fd_sc_hd__fill_1
Xhold293 _2593_/Q VGND VGND VPWR VPWR _2022_/A sky130_fd_sc_hd__dlygate4sd3_1
XTAP_TAPCELL_ROW_68_490 VGND VPWR sky130_fd_sc_hd__tapvpwrvgnd_1
XFILLER_65_65 VGND VGND VPWR VPWR sky130_fd_sc_hd__fill_2
XFILLER_45_123 VGND VGND VPWR VPWR sky130_fd_sc_hd__fill_1
X_2380_ _1240_/Y _2379_/Y _2380_/S VGND VGND VPWR VPWR _2444_/D sky130_fd_sc_hd__mux2i_1
X_1400_ _1486_/A _2283_/A VGND VGND VPWR VPWR _1421_/B sky130_fd_sc_hd__xnor2_1
X_1331_ _1331_/A _1331_/B VGND VGND VPWR VPWR _1332_/B sky130_fd_sc_hd__xnor2_1
X_1193_ _2230_/A VGND VGND VPWR VPWR _2272_/B sky130_fd_sc_hd__inv_1
X_1262_ _2410_/Q _2409_/Q _1262_/C VGND VGND VPWR VPWR _1264_/A sky130_fd_sc_hd__nand3_1
X_2578_ _2634_/CLK _2578_/D load_slew177/X VGND VGND VPWR VPWR _2578_/Q sky130_fd_sc_hd__dfrtp_1
X_1529_ _2627_/Q _1524_/Y _1528_/X _2628_/Q VGND VGND VPWR VPWR _1529_/X sky130_fd_sc_hd__a22o_1
XFILLER_19_69 VGND VGND VPWR VPWR sky130_fd_sc_hd__fill_1
XTAP_TAPCELL_ROW_40_349 VGND VPWR sky130_fd_sc_hd__tapvpwrvgnd_1
XPHY_EDGE_ROW_14_Right_14 VGND VGND VPWR VPWR sky130_fd_sc_hd__decap_3
XFILLER_2_288 VGND VGND VPWR VPWR sky130_fd_sc_hd__fill_1
XPHY_EDGE_ROW_23_Right_23 VGND VGND VPWR VPWR sky130_fd_sc_hd__decap_3
XFILLER_65_229 VGND VGND VPWR VPWR sky130_fd_sc_hd__fill_2
XFILLER_65_207 VGND VGND VPWR VPWR sky130_fd_sc_hd__fill_1
XFILLER_58_281 VGND VGND VPWR VPWR sky130_fd_sc_hd__decap_8
XPHY_EDGE_ROW_32_Right_32 VGND VGND VPWR VPWR sky130_fd_sc_hd__decap_3
X_1880_ _1951_/B _1878_/Y _1879_/Y VGND VGND VPWR VPWR _1880_/Y sky130_fd_sc_hd__o21ai_0
XTAP_TAPCELL_ROW_31_305 VGND VPWR sky130_fd_sc_hd__tapvpwrvgnd_1
XFILLER_18_189 VGND VGND VPWR VPWR sky130_fd_sc_hd__decap_6
X_2501_ _2607_/CLK _2501_/D _2494_/SET_B VGND VGND VPWR VPWR _2501_/Q sky130_fd_sc_hd__dfrtp_1
XFILLER_44_3 VGND VGND VPWR VPWR sky130_fd_sc_hd__decap_8
XPHY_EDGE_ROW_41_Right_41 VGND VGND VPWR VPWR sky130_fd_sc_hd__decap_3
X_1314_ _1299_/Y _1305_/B _1311_/A _1308_/Y _1298_/Y VGND VGND VPWR VPWR wire43/A
+ sky130_fd_sc_hd__o311ai_1
X_2294_ _2294_/A _2294_/B VGND VGND VPWR VPWR _2296_/A sky130_fd_sc_hd__nor2_1
X_2363_ _2316_/B _2331_/B _2297_/A VGND VGND VPWR VPWR _2363_/Y sky130_fd_sc_hd__a21oi_1
X_2432_ clkload3/A _2432_/D fanout163/X VGND VGND VPWR VPWR _2432_/Q sky130_fd_sc_hd__dfstp_2
X_1245_ _2464_/Q VGND VGND VPWR VPWR _1245_/Y sky130_fd_sc_hd__inv_1
XTAP_TAPCELL_ROW_54_419 VGND VPWR sky130_fd_sc_hd__tapvpwrvgnd_1
XPHY_EDGE_ROW_50_Right_50 VGND VGND VPWR VPWR sky130_fd_sc_hd__decap_3
XFILLER_32_181 VGND VGND VPWR VPWR sky130_fd_sc_hd__decap_3
Xmax_cap35 _1482_/Y VGND VGND VPWR VPWR _1523_/B sky130_fd_sc_hd__buf_1
Xmax_cap24 _1455_/B VGND VGND VPWR VPWR _2098_/D sky130_fd_sc_hd__clkbuf_2
Xmax_cap57 _2080_/C VGND VGND VPWR VPWR _2083_/B1 sky130_fd_sc_hd__clkdlybuf4s25_1
XFILLER_15_148 VGND VGND VPWR VPWR sky130_fd_sc_hd__decap_12
X_1932_ _2543_/Q _2569_/Q _1932_/S VGND VGND VPWR VPWR _1932_/Y sky130_fd_sc_hd__mux2i_1
X_1863_ _2520_/Q _2594_/Q _1926_/S VGND VGND VPWR VPWR _1863_/Y sky130_fd_sc_hd__mux2i_1
X_1794_ _2495_/Q _2634_/Q _2496_/Q VGND VGND VPWR VPWR _1798_/C sky130_fd_sc_hd__and3_1
X_2415_ clkload4/A _2415_/D _2437_/SET_B VGND VGND VPWR VPWR _2415_/Q sky130_fd_sc_hd__dfrtp_1
X_2277_ _2257_/A _1512_/A _2258_/Y VGND VGND VPWR VPWR _2279_/B sky130_fd_sc_hd__o21ai_0
X_2346_ _2351_/A _2346_/B _2346_/C VGND VGND VPWR VPWR _2348_/A sky130_fd_sc_hd__nand3_1
X_1228_ _2456_/Q VGND VGND VPWR VPWR _1228_/Y sky130_fd_sc_hd__inv_1
XFILLER_52_232 VGND VGND VPWR VPWR sky130_fd_sc_hd__decap_8
XTAP_TAPCELL_ROW_50_400 VGND VPWR sky130_fd_sc_hd__tapvpwrvgnd_1
XFILLER_11_173 VGND VGND VPWR VPWR sky130_fd_sc_hd__fill_1
XFILLER_22_80 VGND VGND VPWR VPWR sky130_fd_sc_hd__decap_4
X_2200_ _2200_/A _2200_/B VGND VGND VPWR VPWR _2203_/A sky130_fd_sc_hd__xnor2_1
X_2131_ _1539_/B _2010_/B _2130_/Y VGND VGND VPWR VPWR _2421_/D sky130_fd_sc_hd__o21ai_0
X_2062_ _2452_/Q hold372/X _2067_/S VGND VGND VPWR VPWR _2394_/D sky130_fd_sc_hd__mux2_1
XFILLER_34_287 VGND VGND VPWR VPWR sky130_fd_sc_hd__fill_2
XFILLER_34_265 VGND VGND VPWR VPWR sky130_fd_sc_hd__decap_6
XFILLER_34_232 VGND VGND VPWR VPWR sky130_fd_sc_hd__fill_1
X_1777_ _1777_/A _1777_/B VGND VGND VPWR VPWR _1777_/Y sky130_fd_sc_hd__xnor2_1
X_1846_ _1846_/A _1945_/B VGND VGND VPWR VPWR _1846_/Y sky130_fd_sc_hd__nand2_1
XFILLER_8_93 VGND VGND VPWR VPWR sky130_fd_sc_hd__decap_4
Xclkbuf_leaf_14_clk clkbuf_leaf_9_clk/A VGND VGND VPWR VPWR clkload7/A sky130_fd_sc_hd__clkbuf_16
X_1915_ _1915_/A _1948_/B VGND VGND VPWR VPWR _1915_/Y sky130_fd_sc_hd__nand2_1
XPHY_EDGE_ROW_4_Right_4 VGND VGND VPWR VPWR sky130_fd_sc_hd__decap_3
XTAP_TAPCELL_ROW_4_169 VGND VPWR sky130_fd_sc_hd__tapvpwrvgnd_1
X_2329_ _2289_/A _2359_/S _2328_/Y VGND VGND VPWR VPWR _2329_/Y sky130_fd_sc_hd__a21oi_1
XFILLER_25_210 VGND VGND VPWR VPWR sky130_fd_sc_hd__fill_1
XTAP_TAPCELL_ROW_70_506 VGND VPWR sky130_fd_sc_hd__tapvpwrvgnd_1
XFILLER_25_254 VGND VGND VPWR VPWR sky130_fd_sc_hd__decap_4
XFILLER_25_265 VGND VGND VPWR VPWR sky130_fd_sc_hd__fill_2
XFILLER_25_287 VGND VGND VPWR VPWR sky130_fd_sc_hd__fill_2
XFILLER_4_114 VGND VGND VPWR VPWR sky130_fd_sc_hd__decap_8
XFILLER_4_29 VGND VGND VPWR VPWR sky130_fd_sc_hd__fill_2
XTAP_TAPCELL_ROW_18_238 VGND VPWR sky130_fd_sc_hd__tapvpwrvgnd_1
X_1631_ _2383_/A _2460_/Q VGND VGND VPWR VPWR _1631_/Y sky130_fd_sc_hd__nand2_1
X_1700_ _1702_/B _1700_/B VGND VGND VPWR VPWR _1700_/Y sky130_fd_sc_hd__nand2_1
X_1493_ _2619_/Q _2618_/Q _2617_/Q VGND VGND VPWR VPWR _1573_/C sky130_fd_sc_hd__and3_1
Xclkbuf_leaf_3_clk clkload0/A VGND VGND VPWR VPWR clkload9/A sky130_fd_sc_hd__clkbuf_16
X_1562_ _1255_/Y _1559_/Y _2052_/C _1651_/C VGND VGND VPWR VPWR _1563_/C sky130_fd_sc_hd__a22oi_1
X_2045_ _1244_/Y _1999_/S _2044_/Y VGND VGND VPWR VPWR _2604_/D sky130_fd_sc_hd__a21oi_1
XTAP_TAPCELL_ROW_49_396 VGND VPWR sky130_fd_sc_hd__tapvpwrvgnd_1
X_2114_ _2419_/Q _2114_/B _2114_/C wire16/X VGND VGND VPWR VPWR _2114_/X sky130_fd_sc_hd__or4_1
Xfanout28 _2168_/A VGND VGND VPWR VPWR _2167_/A sky130_fd_sc_hd__clkdlybuf4s50_1
Xfanout17 _1537_/X VGND VGND VPWR VPWR _1603_/A sky130_fd_sc_hd__clkdlybuf4s50_1
X_1829_ _1829_/A _1829_/B VGND VGND VPWR VPWR _2509_/D sky130_fd_sc_hd__xnor2_1
XFILLER_38_24 VGND VGND VPWR VPWR sky130_fd_sc_hd__decap_4
XFILLER_54_23 VGND VGND VPWR VPWR sky130_fd_sc_hd__decap_4
XTAP_TAPCELL_ROW_0_150 VGND VPWR sky130_fd_sc_hd__tapvpwrvgnd_1
XFILLER_13_213 VGND VGND VPWR VPWR sky130_fd_sc_hd__decap_6
XTAP_TAPCELL_ROW_23_263 VGND VPWR sky130_fd_sc_hd__tapvpwrvgnd_1
XTAP_TAPCELL_ROW_46_377 VGND VPWR sky130_fd_sc_hd__tapvpwrvgnd_1
X_2594_ clkload6/A _2594_/D fanout145/X VGND VGND VPWR VPWR _2594_/Q sky130_fd_sc_hd__dfrtp_1
XFILLER_8_250 VGND VGND VPWR VPWR sky130_fd_sc_hd__fill_2
XFILLER_8_261 VGND VGND VPWR VPWR sky130_fd_sc_hd__fill_1
X_1614_ _1234_/Y _1613_/Y _1628_/S VGND VGND VPWR VPWR _2450_/D sky130_fd_sc_hd__mux2i_1
X_1476_ _2185_/B _2187_/B _2171_/A VGND VGND VPWR VPWR _1496_/A sky130_fd_sc_hd__nor3_1
X_1545_ _2167_/A _1541_/Y _1544_/Y VGND VGND VPWR VPWR _1545_/Y sky130_fd_sc_hd__a21oi_1
XFILLER_54_135 VGND VGND VPWR VPWR sky130_fd_sc_hd__fill_1
XTAP_TAPCELL_ROW_37_333 VGND VPWR sky130_fd_sc_hd__tapvpwrvgnd_1
X_2028_ _2028_/A _2028_/B VGND VGND VPWR VPWR _2028_/Y sky130_fd_sc_hd__nor2_1
XFILLER_62_190 VGND VGND VPWR VPWR sky130_fd_sc_hd__fill_1
XFILLER_10_227 VGND VGND VPWR VPWR sky130_fd_sc_hd__decap_8
Xhold283 _2580_/Q VGND VGND VPWR VPWR hold283/X sky130_fd_sc_hd__dlygate4sd3_1
Xhold272 _1998_/X VGND VGND VPWR VPWR _2578_/D sky130_fd_sc_hd__dlygate4sd3_1
Xhold250 _1913_/Y VGND VGND VPWR VPWR _2537_/D sky130_fd_sc_hd__dlygate4sd3_1
Xhold261 _2564_/Q VGND VGND VPWR VPWR hold261/X sky130_fd_sc_hd__dlygate4sd3_1
Xhold294 _2568_/Q VGND VGND VPWR VPWR hold294/X sky130_fd_sc_hd__dlygate4sd3_1
XTAP_TAPCELL_ROW_68_491 VGND VPWR sky130_fd_sc_hd__tapvpwrvgnd_1
XFILLER_45_113 VGND VGND VPWR VPWR sky130_fd_sc_hd__fill_2
XFILLER_60_138 VGND VGND VPWR VPWR sky130_fd_sc_hd__fill_2
XFILLER_5_253 VGND VGND VPWR VPWR sky130_fd_sc_hd__fill_1
XFILLER_68_205 VGND VGND VPWR VPWR sky130_fd_sc_hd__decap_3
X_1330_ _1340_/A _1340_/B _1340_/C _1341_/A VGND VGND VPWR VPWR _1331_/B sky130_fd_sc_hd__a31oi_1
X_1261_ _2410_/Q _2409_/Q VGND VGND VPWR VPWR _2082_/B sky130_fd_sc_hd__nand2_1
X_1192_ _2287_/B VGND VGND VPWR VPWR _1519_/A sky130_fd_sc_hd__inv_1
XFILLER_36_179 VGND VGND VPWR VPWR sky130_fd_sc_hd__fill_1
XFILLER_44_190 VGND VGND VPWR VPWR sky130_fd_sc_hd__decap_6
X_2577_ clkload9/A _2577_/D load_slew166/X VGND VGND VPWR VPWR _2577_/Q sky130_fd_sc_hd__dfrtp_1
X_1459_ _2613_/Q _2612_/Q VGND VGND VPWR VPWR _1459_/X sky130_fd_sc_hd__xor2_1
XFILLER_67_260 VGND VGND VPWR VPWR sky130_fd_sc_hd__fill_1
X_1528_ _1486_/Y _1527_/Y _1530_/A VGND VGND VPWR VPWR _1528_/X sky130_fd_sc_hd__o21a_1
XTAP_TAPCELL_ROW_65_472 VGND VPWR sky130_fd_sc_hd__tapvpwrvgnd_1
XFILLER_42_105 VGND VGND VPWR VPWR sky130_fd_sc_hd__decap_6
XFILLER_35_190 VGND VGND VPWR VPWR sky130_fd_sc_hd__fill_2
XFILLER_27_157 VGND VGND VPWR VPWR sky130_fd_sc_hd__fill_1
XFILLER_18_135 VGND VGND VPWR VPWR sky130_fd_sc_hd__fill_1
XTAP_TAPCELL_ROW_31_306 VGND VPWR sky130_fd_sc_hd__tapvpwrvgnd_1
X_2500_ _2634_/CLK _2500_/D _2494_/SET_B VGND VGND VPWR VPWR _2500_/Q sky130_fd_sc_hd__dfrtp_1
X_2431_ _2616_/CLK _2431_/D fanout185/X VGND VGND VPWR VPWR _2431_/Q sky130_fd_sc_hd__dfstp_2
X_1244_ _2463_/Q VGND VGND VPWR VPWR _1244_/Y sky130_fd_sc_hd__inv_1
X_1313_ _2287_/B _2230_/A VGND VGND VPWR VPWR _1340_/A sky130_fd_sc_hd__xor2_1
X_2362_ _1413_/C _2355_/Y _1364_/B VGND VGND VPWR VPWR _2362_/Y sky130_fd_sc_hd__o21ai_0
X_2293_ _2293_/A VGND VGND VPWR VPWR _2294_/B sky130_fd_sc_hd__inv_1
X_2629_ clkload3/A _2629_/D fanout161/X VGND VGND VPWR VPWR _2629_/Q sky130_fd_sc_hd__dfrtp_1
XFILLER_46_68 VGND VGND VPWR VPWR sky130_fd_sc_hd__fill_2
XFILLER_46_46 VGND VGND VPWR VPWR sky130_fd_sc_hd__fill_1
Xmax_cap58 _2375_/C VGND VGND VPWR VPWR _2080_/C sky130_fd_sc_hd__clkdlybuf4s25_1
XFILLER_70_233 VGND VGND VPWR VPWR sky130_fd_sc_hd__fill_1
XFILLER_62_56 VGND VGND VPWR VPWR sky130_fd_sc_hd__fill_1
XFILLER_38_219 VGND VGND VPWR VPWR sky130_fd_sc_hd__fill_2
XFILLER_61_266 VGND VGND VPWR VPWR sky130_fd_sc_hd__decap_12
XFILLER_61_288 VGND VGND VPWR VPWR sky130_fd_sc_hd__fill_1
X_1793_ _1793_/A _2634_/Q VGND VGND VPWR VPWR _1793_/X sky130_fd_sc_hd__xor2_1
X_1862_ _1933_/B _1860_/Y _1861_/Y VGND VGND VPWR VPWR _2520_/D sky130_fd_sc_hd__o21ai_0
X_1931_ _1930_/B _1929_/Y _1930_/Y VGND VGND VPWR VPWR _2543_/D sky130_fd_sc_hd__o21ai_0
XFILLER_14_160 VGND VGND VPWR VPWR sky130_fd_sc_hd__fill_2
X_2414_ clkload4/A _2414_/D _2437_/SET_B VGND VGND VPWR VPWR _2414_/Q sky130_fd_sc_hd__dfrtp_1
X_2276_ _2276_/A _2290_/B VGND VGND VPWR VPWR _2279_/A sky130_fd_sc_hd__nor2_1
X_2345_ _2307_/A _2359_/S _2344_/Y _2360_/A VGND VGND VPWR VPWR _2345_/Y sky130_fd_sc_hd__a211oi_1
X_1227_ _2457_/Q VGND VGND VPWR VPWR _1227_/Y sky130_fd_sc_hd__inv_1
XFILLER_52_277 VGND VGND VPWR VPWR sky130_fd_sc_hd__decap_12
XTAP_TAPCELL_ROW_50_401 VGND VPWR sky130_fd_sc_hd__tapvpwrvgnd_1
XFILLER_32_37 VGND VGND VPWR VPWR sky130_fd_sc_hd__fill_2
XFILLER_20_141 VGND VGND VPWR VPWR sky130_fd_sc_hd__fill_1
XFILLER_20_174 VGND VGND VPWR VPWR sky130_fd_sc_hd__fill_1
X_2130_ _2130_/A _2130_/B _2130_/C _2130_/D VGND VGND VPWR VPWR _2130_/Y sky130_fd_sc_hd__nand4_1
XFILLER_34_200 VGND VGND VPWR VPWR sky130_fd_sc_hd__decap_12
X_2061_ _2451_/Q _2393_/Q _2067_/S VGND VGND VPWR VPWR _2393_/D sky130_fd_sc_hd__mux2_1
X_1914_ _2537_/Q _2563_/Q _1917_/S VGND VGND VPWR VPWR _1914_/Y sky130_fd_sc_hd__mux2i_1
X_1776_ _2464_/Q _2406_/Q VGND VGND VPWR VPWR _1777_/B sky130_fd_sc_hd__xnor2_1
X_1845_ _2514_/Q hold378/X _1884_/S VGND VGND VPWR VPWR _1845_/Y sky130_fd_sc_hd__mux2i_1
X_2328_ _2331_/A _2359_/S VGND VGND VPWR VPWR _2328_/Y sky130_fd_sc_hd__nor2_1
X_2259_ _2259_/A _2259_/B VGND VGND VPWR VPWR _2260_/C sky130_fd_sc_hd__xnor2_1
XFILLER_31_236 VGND VGND VPWR VPWR sky130_fd_sc_hd__decap_12
XFILLER_31_225 VGND VGND VPWR VPWR sky130_fd_sc_hd__decap_4
XFILLER_16_233 VGND VGND VPWR VPWR sky130_fd_sc_hd__fill_1
XFILLER_16_288 VGND VGND VPWR VPWR sky130_fd_sc_hd__fill_1
XFILLER_17_92 VGND VGND VPWR VPWR sky130_fd_sc_hd__decap_12
XTAP_TAPCELL_ROW_18_239 VGND VPWR sky130_fd_sc_hd__tapvpwrvgnd_1
X_1630_ _1226_/Y _1629_/Y _2380_/S VGND VGND VPWR VPWR _2458_/D sky130_fd_sc_hd__mux2i_1
X_1492_ _2137_/A _1477_/B _1469_/Y locked VGND VGND VPWR VPWR _1504_/B sky130_fd_sc_hd__o211a_1
X_1561_ _1651_/B _1561_/B VGND VGND VPWR VPWR _2052_/C sky130_fd_sc_hd__nor2_1
X_2044_ _2044_/A _2050_/B VGND VGND VPWR VPWR _2044_/Y sky130_fd_sc_hd__nor2_1
X_2113_ _2111_/Y _2112_/Y _2101_/Y VGND VGND VPWR VPWR _2418_/D sky130_fd_sc_hd__o21ba_1
Xfanout18 _1537_/X VGND VGND VPWR VPWR _1977_/B sky130_fd_sc_hd__clkdlybuf4s50_1
X_1828_ _1828_/A _1828_/B VGND VGND VPWR VPWR _2508_/D sky130_fd_sc_hd__xor2_1
X_1759_ _1752_/X _1757_/B _1754_/B VGND VGND VPWR VPWR _1763_/A sky130_fd_sc_hd__a21oi_1
XFILLER_1_107 VGND VGND VPWR VPWR sky130_fd_sc_hd__decap_4
XFILLER_57_177 VGND VGND VPWR VPWR sky130_fd_sc_hd__decap_12
XFILLER_57_199 VGND VGND VPWR VPWR sky130_fd_sc_hd__decap_3
XTAP_TAPCELL_ROW_0_151 VGND VPWR sky130_fd_sc_hd__tapvpwrvgnd_1
XFILLER_9_207 VGND VGND VPWR VPWR sky130_fd_sc_hd__fill_2
XFILLER_13_203 VGND VGND VPWR VPWR sky130_fd_sc_hd__fill_2
XFILLER_13_225 VGND VGND VPWR VPWR sky130_fd_sc_hd__fill_1
XFILLER_13_258 VGND VGND VPWR VPWR sky130_fd_sc_hd__decap_3
XFILLER_70_23 VGND VGND VPWR VPWR sky130_fd_sc_hd__decap_4
XTAP_TAPCELL_ROW_23_264 VGND VPWR sky130_fd_sc_hd__tapvpwrvgnd_1
XFILLER_63_169 VGND VGND VPWR VPWR sky130_fd_sc_hd__decap_4
XFILLER_48_144 VGND VGND VPWR VPWR sky130_fd_sc_hd__decap_4
XTAP_TAPCELL_ROW_46_378 VGND VPWR sky130_fd_sc_hd__tapvpwrvgnd_1
XTAP_TAPCELL_ROW_14_220 VGND VPWR sky130_fd_sc_hd__tapvpwrvgnd_1
XFILLER_67_3 VGND VGND VPWR VPWR sky130_fd_sc_hd__decap_8
X_2593_ clkload6/A _2593_/D fanout145/X VGND VGND VPWR VPWR _2593_/Q sky130_fd_sc_hd__dfrtp_1
X_1544_ _2101_/A _2096_/A _1543_/Y VGND VGND VPWR VPWR _1544_/Y sky130_fd_sc_hd__o21ai_0
X_1613_ _1627_/A _2451_/Q VGND VGND VPWR VPWR _1613_/Y sky130_fd_sc_hd__nand2_1
X_1475_ _2158_/B _1484_/B VGND VGND VPWR VPWR _1488_/A sky130_fd_sc_hd__nand2_1
XFILLER_39_188 VGND VGND VPWR VPWR sky130_fd_sc_hd__decap_6
XTAP_TAPCELL_ROW_37_334 VGND VPWR sky130_fd_sc_hd__tapvpwrvgnd_1
X_2027_ _1230_/Y _2028_/B _2026_/Y VGND VGND VPWR VPWR _2595_/D sky130_fd_sc_hd__a21oi_1
XFILLER_40_15 VGND VGND VPWR VPWR sky130_fd_sc_hd__decap_12
Xhold262 _2556_/Q VGND VGND VPWR VPWR _1969_/A sky130_fd_sc_hd__dlygate4sd3_1
Xhold284 _2000_/X VGND VGND VPWR VPWR _2580_/D sky130_fd_sc_hd__dlygate4sd3_1
Xhold240 _1958_/Y VGND VGND VPWR VPWR _2552_/D sky130_fd_sc_hd__dlygate4sd3_1
Xhold251 _2511_/Q VGND VGND VPWR VPWR hold251/X sky130_fd_sc_hd__dlygate4sd3_1
XFILLER_49_57 VGND VGND VPWR VPWR sky130_fd_sc_hd__fill_1
Xhold273 _2569_/Q VGND VGND VPWR VPWR hold273/X sky130_fd_sc_hd__dlygate4sd3_1
Xhold295 _2591_/Q VGND VGND VPWR VPWR _2018_/A sky130_fd_sc_hd__dlygate4sd3_1
XFILLER_65_23 VGND VGND VPWR VPWR sky130_fd_sc_hd__fill_1
XFILLER_45_158 VGND VGND VPWR VPWR sky130_fd_sc_hd__decap_8
XFILLER_60_128 VGND VGND VPWR VPWR sky130_fd_sc_hd__fill_1
X_1260_ i2s_sd VGND VGND VPWR VPWR _1260_/Y sky130_fd_sc_hd__inv_1
XFILLER_51_106 VGND VGND VPWR VPWR sky130_fd_sc_hd__fill_2
XFILLER_59_206 VGND VGND VPWR VPWR sky130_fd_sc_hd__fill_1
X_2576_ clkload9/A _2576_/D load_slew168/X VGND VGND VPWR VPWR _2576_/Q sky130_fd_sc_hd__dfrtp_1
X_1527_ _2272_/A locked VGND VGND VPWR VPWR _1527_/Y sky130_fd_sc_hd__nand2_1
XFILLER_10_29 VGND VGND VPWR VPWR sky130_fd_sc_hd__decap_4
X_1458_ _2613_/Q _2612_/Q VGND VGND VPWR VPWR _1458_/Y sky130_fd_sc_hd__xnor2_1
X_1389_ _2213_/B _1389_/B _1429_/B VGND VGND VPWR VPWR _1428_/A sky130_fd_sc_hd__maj3_1
XTAP_TAPCELL_ROW_65_473 VGND VPWR sky130_fd_sc_hd__tapvpwrvgnd_1
XFILLER_42_139 VGND VGND VPWR VPWR sky130_fd_sc_hd__fill_1
XFILLER_2_246 VGND VGND VPWR VPWR sky130_fd_sc_hd__fill_2
X_2430_ clkload3/A _2430_/D fanout185/X VGND VGND VPWR VPWR _2430_/Q sky130_fd_sc_hd__dfstp_2
X_2361_ fanout3/X _2358_/Y _2360_/Y _2096_/A _2316_/B VGND VGND VPWR VPWR _2437_/D
+ sky130_fd_sc_hd__o32a_1
XFILLER_56_209 VGND VGND VPWR VPWR sky130_fd_sc_hd__decap_6
X_1243_ _2462_/Q VGND VGND VPWR VPWR _1243_/Y sky130_fd_sc_hd__inv_1
X_1312_ _2477_/Q _1305_/Y _1311_/X _2478_/Q _1307_/Y VGND VGND VPWR VPWR _1312_/Y
+ sky130_fd_sc_hd__a221oi_1
XFILLER_2_85 VGND VGND VPWR VPWR sky130_fd_sc_hd__fill_2
X_2292_ _2290_/A _2290_/B _2290_/C VGND VGND VPWR VPWR _2293_/A sky130_fd_sc_hd__o21ai_0
XFILLER_32_161 VGND VGND VPWR VPWR sky130_fd_sc_hd__decap_12
X_2559_ _2633_/CLK _2559_/D fanout187/X VGND VGND VPWR VPWR i2s_bclk sky130_fd_sc_hd__dfrtp_1
X_2628_ clkload3/A _2628_/D _2429_/SET_B VGND VGND VPWR VPWR _2628_/Q sky130_fd_sc_hd__dfrtp_1
XFILLER_55_275 VGND VGND VPWR VPWR sky130_fd_sc_hd__decap_4
XFILLER_55_220 VGND VGND VPWR VPWR sky130_fd_sc_hd__decap_4
Xmax_cap15 wire16/X VGND VGND VPWR VPWR _2102_/D sky130_fd_sc_hd__clkbuf_2
XFILLER_62_46 VGND VGND VPWR VPWR sky130_fd_sc_hd__fill_2
XFILLER_61_278 VGND VGND VPWR VPWR sky130_fd_sc_hd__fill_2
XFILLER_61_245 VGND VGND VPWR VPWR sky130_fd_sc_hd__fill_1
XFILLER_61_223 VGND VGND VPWR VPWR sky130_fd_sc_hd__fill_1
XFILLER_46_253 VGND VGND VPWR VPWR sky130_fd_sc_hd__decap_8
X_1930_ _1930_/A _1930_/B VGND VGND VPWR VPWR _1930_/Y sky130_fd_sc_hd__nand2_1
X_1792_ _1259_/Y _2003_/S _1791_/Y VGND VGND VPWR VPWR _2494_/D sky130_fd_sc_hd__o21ai_0
X_1861_ _1861_/A _1933_/B VGND VGND VPWR VPWR _1861_/Y sky130_fd_sc_hd__nand2_1
XPHY_EDGE_ROW_26_Left_97 VGND VGND VPWR VPWR sky130_fd_sc_hd__decap_3
X_2413_ _2592_/CLK _2413_/D load_slew147/X VGND VGND VPWR VPWR _2413_/Q sky130_fd_sc_hd__dfrtp_1
X_2344_ _2351_/A _2359_/S VGND VGND VPWR VPWR _2344_/Y sky130_fd_sc_hd__nor2_1
Xclkbuf_1_0__f_clk clkbuf_0_clk/X VGND VGND VPWR VPWR clkbuf_leaf_9_clk/A sky130_fd_sc_hd__clkbuf_16
XFILLER_52_223 VGND VGND VPWR VPWR sky130_fd_sc_hd__decap_4
XFILLER_52_201 VGND VGND VPWR VPWR sky130_fd_sc_hd__decap_8
X_1226_ _2458_/Q VGND VGND VPWR VPWR _1226_/Y sky130_fd_sc_hd__inv_1
X_2275_ _2482_/Q _2275_/B VGND VGND VPWR VPWR _2290_/B sky130_fd_sc_hd__and2_0
XFILLER_52_267 VGND VGND VPWR VPWR sky130_fd_sc_hd__decap_6
XFILLER_32_27 VGND VGND VPWR VPWR sky130_fd_sc_hd__fill_1
XFILLER_57_46 VGND VGND VPWR VPWR sky130_fd_sc_hd__decap_8
XFILLER_43_201 VGND VGND VPWR VPWR sky130_fd_sc_hd__fill_1
XFILLER_28_264 VGND VGND VPWR VPWR sky130_fd_sc_hd__fill_2
XFILLER_7_146 VGND VGND VPWR VPWR sky130_fd_sc_hd__decap_12
XFILLER_7_113 VGND VGND VPWR VPWR sky130_fd_sc_hd__fill_2
XFILLER_34_212 VGND VGND VPWR VPWR sky130_fd_sc_hd__fill_1
X_2060_ _2450_/Q _2392_/Q _2060_/S VGND VGND VPWR VPWR _2392_/D sky130_fd_sc_hd__mux2_1
XFILLER_19_220 VGND VGND VPWR VPWR sky130_fd_sc_hd__decap_4
XFILLER_34_245 VGND VGND VPWR VPWR sky130_fd_sc_hd__decap_6
X_1913_ _1948_/B _1911_/Y _1912_/Y VGND VGND VPWR VPWR _1913_/Y sky130_fd_sc_hd__o21ai_0
XTAP_TAPCELL_ROW_29_292 VGND VPWR sky130_fd_sc_hd__tapvpwrvgnd_1
X_1775_ _2464_/Q _2406_/Q VGND VGND VPWR VPWR _2119_/D sky130_fd_sc_hd__nor2_1
X_1844_ _1954_/B _1842_/Y _1843_/Y VGND VGND VPWR VPWR _1844_/Y sky130_fd_sc_hd__o21ai_0
X_2258_ _2481_/Q _2259_/B VGND VGND VPWR VPWR _2258_/Y sky130_fd_sc_hd__nand2_1
X_2327_ _2331_/A _2327_/B VGND VGND VPWR VPWR _2327_/Y sky130_fd_sc_hd__nor2_1
X_2189_ _2189_/A _2189_/B VGND VGND VPWR VPWR _2189_/Y sky130_fd_sc_hd__nand2_1
X_1209_ _2480_/Q VGND VGND VPWR VPWR _1692_/A sky130_fd_sc_hd__inv_1
XFILLER_27_49 VGND VGND VPWR VPWR sky130_fd_sc_hd__decap_4
XFILLER_31_248 VGND VGND VPWR VPWR sky130_fd_sc_hd__decap_8
XFILLER_16_245 VGND VGND VPWR VPWR sky130_fd_sc_hd__decap_6
XFILLER_17_82 VGND VGND VPWR VPWR sky130_fd_sc_hd__decap_6
X_1560_ _2096_/A _1560_/B _2168_/B VGND VGND VPWR VPWR _1560_/Y sky130_fd_sc_hd__nand3_1
X_1491_ _2198_/A _1507_/A VGND VGND VPWR VPWR _1491_/Y sky130_fd_sc_hd__xnor2_1
X_2112_ _1550_/B _2108_/B _2108_/C _1550_/A VGND VGND VPWR VPWR _2112_/Y sky130_fd_sc_hd__a31oi_1
X_2043_ _1243_/Y _2042_/B _2042_/Y VGND VGND VPWR VPWR _2603_/D sky130_fd_sc_hd__a21oi_1
X_1827_ _1828_/B _1827_/B VGND VGND VPWR VPWR _2507_/D sky130_fd_sc_hd__nor2_1
XFILLER_22_248 VGND VGND VPWR VPWR sky130_fd_sc_hd__fill_1
X_1758_ hold318/X _1757_/Y _1999_/S VGND VGND VPWR VPWR _2488_/D sky130_fd_sc_hd__mux2_1
X_1689_ _1671_/Y _1688_/Y _2136_/A VGND VGND VPWR VPWR _2478_/D sky130_fd_sc_hd__a21oi_1
XFILLER_57_189 VGND VGND VPWR VPWR sky130_fd_sc_hd__decap_4
XPHY_EDGE_ROW_13_Left_84 VGND VGND VPWR VPWR sky130_fd_sc_hd__decap_3
XFILLER_70_57 VGND VGND VPWR VPWR sky130_fd_sc_hd__decap_4
XFILLER_21_281 VGND VGND VPWR VPWR sky130_fd_sc_hd__decap_8
XTAP_TAPCELL_ROW_23_265 VGND VPWR sky130_fd_sc_hd__tapvpwrvgnd_1
XFILLER_63_126 VGND VGND VPWR VPWR sky130_fd_sc_hd__fill_1
XFILLER_48_167 VGND VGND VPWR VPWR sky130_fd_sc_hd__fill_2
XFILLER_48_156 VGND VGND VPWR VPWR sky130_fd_sc_hd__decap_3
XTAP_TAPCELL_ROW_46_379 VGND VPWR sky130_fd_sc_hd__tapvpwrvgnd_1
XFILLER_8_230 VGND VGND VPWR VPWR sky130_fd_sc_hd__decap_12
XTAP_TAPCELL_ROW_14_221 VGND VPWR sky130_fd_sc_hd__tapvpwrvgnd_1
X_1474_ _1302_/Y _1339_/B _1472_/Y locked VGND VGND VPWR VPWR _1474_/Y sky130_fd_sc_hd__o31ai_1
X_2592_ _2592_/CLK _2592_/D load_slew147/X VGND VGND VPWR VPWR _2592_/Q sky130_fd_sc_hd__dfrtp_1
X_1543_ _2439_/Q _1543_/B _2609_/Q _2440_/Q VGND VGND VPWR VPWR _1543_/Y sky130_fd_sc_hd__nand4b_1
X_1612_ _1235_/Y _1611_/Y _1628_/S VGND VGND VPWR VPWR _2449_/D sky130_fd_sc_hd__mux2i_1
XFILLER_62_170 VGND VGND VPWR VPWR sky130_fd_sc_hd__decap_12
XTAP_TAPCELL_ROW_37_335 VGND VPWR sky130_fd_sc_hd__tapvpwrvgnd_1
X_2026_ _2026_/A _2028_/B VGND VGND VPWR VPWR _2026_/Y sky130_fd_sc_hd__nor2_1
XFILLER_40_38 VGND VGND VPWR VPWR sky130_fd_sc_hd__fill_1
XFILLER_40_27 VGND VGND VPWR VPWR sky130_fd_sc_hd__fill_1
Xhold263 _1970_/Y VGND VGND VPWR VPWR _2556_/D sky130_fd_sc_hd__dlygate4sd3_1
Xhold252 _1835_/X VGND VGND VPWR VPWR _2511_/D sky130_fd_sc_hd__dlygate4sd3_1
Xhold230 _2531_/Q VGND VGND VPWR VPWR _1894_/A sky130_fd_sc_hd__dlygate4sd3_1
XFILLER_49_69 VGND VGND VPWR VPWR sky130_fd_sc_hd__fill_2
Xhold285 _2601_/Q VGND VGND VPWR VPWR _2038_/A sky130_fd_sc_hd__dlygate4sd3_1
Xhold296 _2592_/Q VGND VGND VPWR VPWR _2020_/A sky130_fd_sc_hd__dlygate4sd3_1
Xhold241 _2543_/Q VGND VGND VPWR VPWR _1930_/A sky130_fd_sc_hd__dlygate4sd3_1
Xhold274 _1989_/X VGND VGND VPWR VPWR _2569_/D sky130_fd_sc_hd__dlygate4sd3_1
XFILLER_60_107 VGND VGND VPWR VPWR sky130_fd_sc_hd__decap_4
XFILLER_53_181 VGND VGND VPWR VPWR sky130_fd_sc_hd__decap_12
XTAP_TAPCELL_ROW_11_202 VGND VPWR sky130_fd_sc_hd__tapvpwrvgnd_1
XFILLER_5_222 VGND VGND VPWR VPWR sky130_fd_sc_hd__fill_2
XTAP_TAPCELL_ROW_42_360 VGND VPWR sky130_fd_sc_hd__tapvpwrvgnd_1
X_1526_ _1518_/Y _1521_/Y _1522_/Y _1525_/Y VGND VGND VPWR VPWR _1526_/Y sky130_fd_sc_hd__a31oi_1
X_2575_ clkload1/A _2575_/D load_slew152/X VGND VGND VPWR VPWR _2575_/Q sky130_fd_sc_hd__dfrtp_1
X_1457_ _2442_/Q wire29/X _1373_/X _2098_/D _1375_/Y VGND VGND VPWR VPWR _1651_/C
+ sky130_fd_sc_hd__o41ai_2
XFILLER_67_251 VGND VGND VPWR VPWR sky130_fd_sc_hd__fill_1
XTAP_TAPCELL_ROW_65_474 VGND VPWR sky130_fd_sc_hd__tapvpwrvgnd_1
X_1388_ _1430_/A _1430_/B _1386_/Y VGND VGND VPWR VPWR _1429_/B sky130_fd_sc_hd__o21ai_0
XFILLER_51_15 VGND VGND VPWR VPWR sky130_fd_sc_hd__decap_4
X_2009_ _1239_/Y _2042_/B _2008_/Y VGND VGND VPWR VPWR _2586_/D sky130_fd_sc_hd__a21oi_1
XTAP_TAPCELL_ROW_56_430 VGND VPWR sky130_fd_sc_hd__tapvpwrvgnd_1
XPHY_EDGE_ROW_38_Left_109 VGND VGND VPWR VPWR sky130_fd_sc_hd__decap_3
XFILLER_33_107 VGND VGND VPWR VPWR sky130_fd_sc_hd__decap_4
XPHY_EDGE_ROW_47_Left_118 VGND VGND VPWR VPWR sky130_fd_sc_hd__decap_3
X_1311_ _1311_/A _1311_/B VGND VGND VPWR VPWR _1311_/X sky130_fd_sc_hd__xor2_1
X_2360_ _2360_/A _2360_/B VGND VGND VPWR VPWR _2360_/Y sky130_fd_sc_hd__nor2_1
X_2291_ _2294_/A VGND VGND VPWR VPWR _2291_/Y sky130_fd_sc_hd__inv_1
XPHY_EDGE_ROW_56_Left_127 VGND VGND VPWR VPWR sky130_fd_sc_hd__decap_3
X_1242_ _2461_/Q VGND VGND VPWR VPWR _1242_/Y sky130_fd_sc_hd__inv_1
XFILLER_2_42 VGND VGND VPWR VPWR sky130_fd_sc_hd__fill_2
XPHY_EDGE_ROW_10_Right_10 VGND VGND VPWR VPWR sky130_fd_sc_hd__decap_3
XFILLER_32_195 VGND VGND VPWR VPWR sky130_fd_sc_hd__fill_1
XFILLER_32_173 VGND VGND VPWR VPWR sky130_fd_sc_hd__decap_8
XPHY_EDGE_ROW_65_Left_136 VGND VGND VPWR VPWR sky130_fd_sc_hd__decap_3
X_2627_ clkload3/A _2627_/D _2429_/SET_B VGND VGND VPWR VPWR _2627_/Q sky130_fd_sc_hd__dfrtp_1
X_2558_ _2607_/CLK _2558_/D _2494_/SET_B VGND VGND VPWR VPWR _2558_/Q sky130_fd_sc_hd__dfrtp_1
X_2489_ _2634_/CLK _2489_/D load_slew175/X VGND VGND VPWR VPWR _2489_/Q sky130_fd_sc_hd__dfrtp_1
X_1509_ _1523_/A _1507_/Y _2622_/Q VGND VGND VPWR VPWR _1509_/Y sky130_fd_sc_hd__o21ai_0
XFILLER_70_279 VGND VGND VPWR VPWR sky130_fd_sc_hd__fill_1
XFILLER_46_287 VGND VGND VPWR VPWR sky130_fd_sc_hd__fill_2
XPHY_EDGE_ROW_1_Left_72 VGND VGND VPWR VPWR sky130_fd_sc_hd__decap_3
X_1860_ _2519_/Q _2593_/Q _1926_/S VGND VGND VPWR VPWR _1860_/Y sky130_fd_sc_hd__mux2i_1
X_1791_ _1789_/A _1789_/B _2003_/S _1786_/Y VGND VGND VPWR VPWR _1791_/Y sky130_fd_sc_hd__o211ai_1
XFILLER_42_3 VGND VGND VPWR VPWR sky130_fd_sc_hd__fill_1
X_2274_ _2274_/A _2275_/B VGND VGND VPWR VPWR _2276_/A sky130_fd_sc_hd__nor2_1
X_2412_ _2592_/CLK _2412_/D fanout146/X VGND VGND VPWR VPWR _2412_/Q sky130_fd_sc_hd__dfrtp_1
X_2343_ _2136_/B _2341_/Y _2342_/Y _2327_/Y VGND VGND VPWR VPWR _2435_/D sky130_fd_sc_hd__a31oi_1
XFILLER_52_213 VGND VGND VPWR VPWR sky130_fd_sc_hd__fill_2
X_1225_ _2459_/Q VGND VGND VPWR VPWR _1225_/Y sky130_fd_sc_hd__inv_1
X_1989_ hold273/X _2394_/Q _2028_/B VGND VGND VPWR VPWR _1989_/X sky130_fd_sc_hd__mux2_1
XFILLER_20_121 VGND VGND VPWR VPWR sky130_fd_sc_hd__fill_2
XFILLER_28_232 VGND VGND VPWR VPWR sky130_fd_sc_hd__fill_2
XFILLER_43_213 VGND VGND VPWR VPWR sky130_fd_sc_hd__fill_2
XFILLER_11_121 VGND VGND VPWR VPWR sky130_fd_sc_hd__fill_2
XFILLER_7_169 VGND VGND VPWR VPWR sky130_fd_sc_hd__decap_12
XFILLER_11_143 VGND VGND VPWR VPWR sky130_fd_sc_hd__decap_12
XTAP_TAPCELL_ROW_29_293 VGND VPWR sky130_fd_sc_hd__tapvpwrvgnd_1
XTAP_TAPCELL_ROW_6_180 VGND VPWR sky130_fd_sc_hd__tapvpwrvgnd_1
XFILLER_19_276 VGND VGND VPWR VPWR sky130_fd_sc_hd__decap_4
X_1843_ _1843_/A _1951_/B VGND VGND VPWR VPWR _1843_/Y sky130_fd_sc_hd__nand2_1
X_1912_ _1912_/A _1948_/B VGND VGND VPWR VPWR _1912_/Y sky130_fd_sc_hd__nand2_1
XFILLER_69_110 VGND VGND VPWR VPWR sky130_fd_sc_hd__fill_2
X_1774_ _2464_/Q _2406_/Q VGND VGND VPWR VPWR _1774_/Y sky130_fd_sc_hd__nand2_1
Xclkbuf_leaf_6_clk clkload0/A VGND VGND VPWR VPWR _2606_/CLK sky130_fd_sc_hd__clkbuf_16
XFILLER_6_191 VGND VGND VPWR VPWR sky130_fd_sc_hd__decap_4
X_2257_ _2257_/A _2257_/B VGND VGND VPWR VPWR _2259_/B sky130_fd_sc_hd__xnor2_1
X_2326_ fanout3/X _2315_/Y _2325_/Y _2327_/B _2316_/A VGND VGND VPWR VPWR _2434_/D
+ sky130_fd_sc_hd__o32a_1
X_1208_ _2481_/Q VGND VGND VPWR VPWR _2259_/A sky130_fd_sc_hd__inv_1
X_2188_ _2189_/A _2189_/B VGND VGND VPWR VPWR _2190_/A sky130_fd_sc_hd__nor2_1
XFILLER_25_202 VGND VGND VPWR VPWR sky130_fd_sc_hd__decap_8
XFILLER_25_279 VGND VGND VPWR VPWR sky130_fd_sc_hd__fill_1
XFILLER_16_257 VGND VGND VPWR VPWR sky130_fd_sc_hd__fill_1
X_1490_ _1490_/A _1490_/B VGND VGND VPWR VPWR _1490_/X sky130_fd_sc_hd__and2_0
XFILLER_66_157 VGND VGND VPWR VPWR sky130_fd_sc_hd__fill_1
X_2042_ _2042_/A _2042_/B VGND VGND VPWR VPWR _2042_/Y sky130_fd_sc_hd__nor2_1
X_2111_ _2114_/B _2114_/C wire16/X VGND VGND VPWR VPWR _2111_/Y sky130_fd_sc_hd__nor3_1
XPHY_EDGE_ROW_8_Right_8 VGND VGND VPWR VPWR sky130_fd_sc_hd__decap_3
X_1826_ hold374/X _2633_/Q hold340/X VGND VGND VPWR VPWR _1827_/B sky130_fd_sc_hd__a21oi_1
XFILLER_30_260 VGND VGND VPWR VPWR sky130_fd_sc_hd__fill_1
X_1757_ _1757_/A _1757_/B VGND VGND VPWR VPWR _1757_/Y sky130_fd_sc_hd__xnor2_1
X_1688_ _1688_/A _1688_/B VGND VGND VPWR VPWR _1688_/Y sky130_fd_sc_hd__xnor2_1
XPHY_EDGE_ROW_39_Right_39 VGND VGND VPWR VPWR sky130_fd_sc_hd__decap_3
XTAP_TAPCELL_ROW_0_142 VGND VPWR sky130_fd_sc_hd__tapvpwrvgnd_1
X_2309_ _2322_/A _2322_/B VGND VGND VPWR VPWR _2311_/A sky130_fd_sc_hd__xor2_1
XPHY_EDGE_ROW_48_Right_48 VGND VGND VPWR VPWR sky130_fd_sc_hd__decap_3
XTAP_TAPCELL_ROW_23_266 VGND VPWR sky130_fd_sc_hd__tapvpwrvgnd_1
XPHY_EDGE_ROW_57_Right_57 VGND VGND VPWR VPWR sky130_fd_sc_hd__decap_3
XFILLER_0_197 VGND VGND VPWR VPWR sky130_fd_sc_hd__decap_12
XPHY_EDGE_ROW_66_Right_66 VGND VGND VPWR VPWR sky130_fd_sc_hd__decap_3
XFILLER_8_242 VGND VGND VPWR VPWR sky130_fd_sc_hd__decap_8
XFILLER_8_253 VGND VGND VPWR VPWR sky130_fd_sc_hd__decap_8
XFILLER_8_286 VGND VGND VPWR VPWR sky130_fd_sc_hd__decap_3
X_1611_ _1627_/A _2450_/Q VGND VGND VPWR VPWR _1611_/Y sky130_fd_sc_hd__nand2_1
X_1473_ _1302_/Y _1339_/B _1472_/Y locked VGND VGND VPWR VPWR _1484_/B sky130_fd_sc_hd__o31a_1
X_2591_ clkload2/A _2591_/D load_slew154/X VGND VGND VPWR VPWR _2591_/Q sky130_fd_sc_hd__dfrtp_1
X_1542_ _2439_/Q _1543_/B _2440_/Q VGND VGND VPWR VPWR _1542_/Y sky130_fd_sc_hd__nand3b_1
XFILLER_39_113 VGND VGND VPWR VPWR sky130_fd_sc_hd__fill_1
XTAP_TAPCELL_ROW_37_336 VGND VPWR sky130_fd_sc_hd__tapvpwrvgnd_1
X_2025_ _1231_/Y _2028_/B _2024_/Y VGND VGND VPWR VPWR _2594_/D sky130_fd_sc_hd__a21oi_1
XFILLER_62_182 VGND VGND VPWR VPWR sky130_fd_sc_hd__decap_8
XFILLER_24_29 VGND VGND VPWR VPWR sky130_fd_sc_hd__decap_12
X_1809_ _1809_/A _2488_/Q _1809_/C VGND VGND VPWR VPWR _1810_/C sky130_fd_sc_hd__maj3_1
Xhold242 _2529_/Q VGND VGND VPWR VPWR _1888_/A sky130_fd_sc_hd__dlygate4sd3_1
Xhold253 _2535_/Q VGND VGND VPWR VPWR _1906_/A sky130_fd_sc_hd__dlygate4sd3_1
XTAP_TAPCELL_ROW_20_247 VGND VPWR sky130_fd_sc_hd__tapvpwrvgnd_1
Xhold231 _2467_/Q VGND VGND VPWR VPWR _1464_/B sky130_fd_sc_hd__dlygate4sd3_1
Xhold220 _2524_/Q VGND VGND VPWR VPWR _1873_/A sky130_fd_sc_hd__dlygate4sd3_1
Xhold286 _2603_/Q VGND VGND VPWR VPWR _2042_/A sky130_fd_sc_hd__dlygate4sd3_1
Xhold264 _2514_/Q VGND VGND VPWR VPWR _1843_/A sky130_fd_sc_hd__dlygate4sd3_1
Xhold297 _2563_/Q VGND VGND VPWR VPWR hold297/X sky130_fd_sc_hd__dlygate4sd3_1
Xhold275 _2565_/Q VGND VGND VPWR VPWR hold275/X sky130_fd_sc_hd__dlygate4sd3_1
XFILLER_53_193 VGND VGND VPWR VPWR sky130_fd_sc_hd__fill_2
XFILLER_45_105 VGND VGND VPWR VPWR sky130_fd_sc_hd__decap_6
XTAP_TAPCELL_ROW_11_203 VGND VPWR sky130_fd_sc_hd__tapvpwrvgnd_1
XTAP_TAPCELL_ROW_42_361 VGND VPWR sky130_fd_sc_hd__tapvpwrvgnd_1
XTAP_TAPCELL_ROW_34_317 VGND VPWR sky130_fd_sc_hd__tapvpwrvgnd_1
X_2574_ clkload1/A _2574_/D load_slew150/X VGND VGND VPWR VPWR _2574_/Q sky130_fd_sc_hd__dfrtp_1
X_1387_ _1391_/B _1431_/B VGND VGND VPWR VPWR _1430_/B sky130_fd_sc_hd__xnor2_1
XFILLER_59_219 VGND VGND VPWR VPWR sky130_fd_sc_hd__fill_2
X_1525_ _2626_/Q _1521_/B _1524_/Y _2627_/Q VGND VGND VPWR VPWR _1525_/Y sky130_fd_sc_hd__o22ai_1
X_1456_ _2442_/Q wire29/X _1373_/X _1455_/B _1375_/Y VGND VGND VPWR VPWR _1657_/C
+ sky130_fd_sc_hd__o41a_1
XFILLER_67_285 VGND VGND VPWR VPWR sky130_fd_sc_hd__decap_4
XTAP_TAPCELL_ROW_65_475 VGND VPWR sky130_fd_sc_hd__tapvpwrvgnd_1
X_2008_ _2008_/A _2042_/B VGND VGND VPWR VPWR _2008_/Y sky130_fd_sc_hd__nor2_1
XFILLER_50_141 VGND VGND VPWR VPWR sky130_fd_sc_hd__decap_4
XTAP_TAPCELL_ROW_56_431 VGND VPWR sky130_fd_sc_hd__tapvpwrvgnd_1
XFILLER_26_193 VGND VGND VPWR VPWR sky130_fd_sc_hd__decap_3
X_1241_ _2443_/Q VGND VGND VPWR VPWR _1241_/Y sky130_fd_sc_hd__inv_1
X_1310_ _1299_/Y _1305_/B _1298_/Y VGND VGND VPWR VPWR _1311_/B sky130_fd_sc_hd__o21ai_0
XFILLER_1_281 VGND VGND VPWR VPWR sky130_fd_sc_hd__decap_8
X_2290_ _2290_/A _2290_/B _2290_/C VGND VGND VPWR VPWR _2294_/A sky130_fd_sc_hd__nor3_1
XFILLER_64_222 VGND VGND VPWR VPWR sky130_fd_sc_hd__fill_2
X_2557_ _2607_/CLK _2557_/D _2494_/SET_B VGND VGND VPWR VPWR _2557_/Q sky130_fd_sc_hd__dfrtp_1
X_2626_ clkload3/A _2626_/D _2429_/SET_B VGND VGND VPWR VPWR _2626_/Q sky130_fd_sc_hd__dfrtp_1
X_2488_ _2634_/CLK _2488_/D load_slew175/X VGND VGND VPWR VPWR _2488_/Q sky130_fd_sc_hd__dfrtp_1
X_1508_ _2622_/Q _1523_/A _1507_/Y _1503_/Y _2621_/Q VGND VGND VPWR VPWR _1508_/Y
+ sky130_fd_sc_hd__o32ai_1
XFILLER_46_27 VGND VGND VPWR VPWR sky130_fd_sc_hd__fill_1
X_1439_ _1690_/A _1440_/B _1423_/Y _2478_/Q VGND VGND VPWR VPWR _1439_/Y sky130_fd_sc_hd__o22ai_1
XFILLER_70_225 VGND VGND VPWR VPWR sky130_fd_sc_hd__fill_1
XFILLER_62_26 VGND VGND VPWR VPWR sky130_fd_sc_hd__fill_2
XTAP_TAPCELL_ROW_53_412 VGND VPWR sky130_fd_sc_hd__tapvpwrvgnd_1
Xmax_cap39 _1516_/B VGND VGND VPWR VPWR _1514_/A1 sky130_fd_sc_hd__clkdlybuf4s25_1
XFILLER_2_3 VGND VGND VPWR VPWR sky130_fd_sc_hd__fill_2
XFILLER_11_63 VGND VGND VPWR VPWR sky130_fd_sc_hd__fill_1
XFILLER_61_225 VGND VGND VPWR VPWR sky130_fd_sc_hd__fill_1
X_1790_ _2003_/S _1789_/X _1785_/Y VGND VGND VPWR VPWR _2493_/D sky130_fd_sc_hd__a21oi_1
XFILLER_14_130 VGND VGND VPWR VPWR sky130_fd_sc_hd__fill_2
XFILLER_14_141 VGND VGND VPWR VPWR sky130_fd_sc_hd__fill_1
X_2411_ _2592_/CLK _2411_/D load_slew147/X VGND VGND VPWR VPWR _2411_/Q sky130_fd_sc_hd__dfrtp_1
X_1224_ _2460_/Q VGND VGND VPWR VPWR _1224_/Y sky130_fd_sc_hd__inv_1
XFILLER_35_3 VGND VGND VPWR VPWR sky130_fd_sc_hd__decap_8
X_2273_ _2273_/A _2283_/A VGND VGND VPWR VPWR _2275_/B sky130_fd_sc_hd__xnor2_1
X_2342_ _1557_/A _2329_/Y _1466_/B VGND VGND VPWR VPWR _2342_/Y sky130_fd_sc_hd__a21oi_1
XFILLER_52_247 VGND VGND VPWR VPWR sky130_fd_sc_hd__fill_2
XFILLER_37_255 VGND VGND VPWR VPWR sky130_fd_sc_hd__decap_6
X_1988_ hold294/X _2393_/Q _2020_/B VGND VGND VPWR VPWR _2568_/D sky130_fd_sc_hd__mux2_1
X_2609_ clkload5/A _2609_/D load_slew162/X VGND VGND VPWR VPWR _2609_/Q sky130_fd_sc_hd__dfrtp_1
XFILLER_43_225 VGND VGND VPWR VPWR sky130_fd_sc_hd__decap_12
XFILLER_28_288 VGND VGND VPWR VPWR sky130_fd_sc_hd__fill_1
XFILLER_11_155 VGND VGND VPWR VPWR sky130_fd_sc_hd__fill_2
Xfanout190 fanout191/X VGND VGND VPWR VPWR fanout190/X sky130_fd_sc_hd__clkdlybuf4s50_1
XTAP_TAPCELL_ROW_6_181 VGND VPWR sky130_fd_sc_hd__tapvpwrvgnd_1
XTAP_TAPCELL_ROW_29_294 VGND VPWR sky130_fd_sc_hd__tapvpwrvgnd_1
XFILLER_19_255 VGND VGND VPWR VPWR sky130_fd_sc_hd__decap_4
X_1773_ _1770_/A _1770_/B _1768_/B VGND VGND VPWR VPWR _1777_/A sky130_fd_sc_hd__a21oi_1
X_1842_ _2513_/Q _2587_/Q _1884_/S VGND VGND VPWR VPWR _1842_/Y sky130_fd_sc_hd__mux2i_1
X_1911_ _2536_/Q _2562_/Q _1971_/S VGND VGND VPWR VPWR _1911_/Y sky130_fd_sc_hd__mux2i_1
XFILLER_8_42 VGND VGND VPWR VPWR sky130_fd_sc_hd__fill_2
XFILLER_8_97 VGND VGND VPWR VPWR sky130_fd_sc_hd__fill_1
XFILLER_6_181 VGND VGND VPWR VPWR sky130_fd_sc_hd__decap_6
X_2187_ _2212_/B _2187_/B _2475_/Q VGND VGND VPWR VPWR _2189_/B sky130_fd_sc_hd__maj3_1
X_2256_ _1688_/A _2255_/B _2255_/Y VGND VGND VPWR VPWR _2256_/Y sky130_fd_sc_hd__a21oi_1
X_2325_ _2351_/B _2323_/Y _2324_/Y VGND VGND VPWR VPWR _2325_/Y sky130_fd_sc_hd__a21oi_1
X_1207_ _2274_/A VGND VGND VPWR VPWR _2149_/B sky130_fd_sc_hd__inv_1
XFILLER_25_225 VGND VGND VPWR VPWR sky130_fd_sc_hd__decap_8
XFILLER_31_206 VGND VGND VPWR VPWR sky130_fd_sc_hd__decap_3
XTAP_TAPCELL_ROW_3_162 VGND VPWR sky130_fd_sc_hd__tapvpwrvgnd_1
XFILLER_33_50 VGND VGND VPWR VPWR sky130_fd_sc_hd__fill_2
X_2041_ _1242_/Y _2042_/B _2040_/Y VGND VGND VPWR VPWR _2602_/D sky130_fd_sc_hd__a21oi_1
X_2110_ _2108_/Y _2109_/X _2110_/B1 VGND VGND VPWR VPWR _2417_/D sky130_fd_sc_hd__a21oi_1
XFILLER_22_239 VGND VGND VPWR VPWR sky130_fd_sc_hd__fill_2
X_1825_ _1825_/A _1825_/B VGND VGND VPWR VPWR _2506_/D sky130_fd_sc_hd__xor2_1
X_1756_ _1756_/A _1756_/B VGND VGND VPWR VPWR _1757_/B sky130_fd_sc_hd__nand2_1
XFILLER_30_283 VGND VGND VPWR VPWR sky130_fd_sc_hd__decap_6
X_1687_ _1671_/Y _1686_/Y _2136_/A VGND VGND VPWR VPWR _2477_/D sky130_fd_sc_hd__a21oi_1
X_2308_ _2331_/A _1519_/A _2288_/Y VGND VGND VPWR VPWR _2322_/B sky130_fd_sc_hd__o21ai_0
XFILLER_57_169 VGND VGND VPWR VPWR sky130_fd_sc_hd__fill_1
XFILLER_57_147 VGND VGND VPWR VPWR sky130_fd_sc_hd__fill_1
XFILLER_54_27 VGND VGND VPWR VPWR sky130_fd_sc_hd__fill_1
X_2239_ fanout3/X _2228_/Y _2238_/Y _2136_/A _2201_/A VGND VGND VPWR VPWR _2428_/D
+ sky130_fd_sc_hd__o32a_1
XTAP_TAPCELL_ROW_0_143 VGND VPWR sky130_fd_sc_hd__tapvpwrvgnd_1
XFILLER_70_48 VGND VGND VPWR VPWR sky130_fd_sc_hd__decap_8
X_1610_ _1236_/Y _1609_/Y _1628_/S VGND VGND VPWR VPWR _2448_/D sky130_fd_sc_hd__mux2i_1
X_2590_ clkload2/A _2590_/D fanout156/X VGND VGND VPWR VPWR _2590_/Q sky130_fd_sc_hd__dfrtp_1
X_1472_ _1472_/A _1495_/B _1472_/C _1472_/D VGND VGND VPWR VPWR _1472_/Y sky130_fd_sc_hd__nand4_1
X_1541_ _2442_/Q _2077_/B _1561_/B VGND VGND VPWR VPWR _1541_/Y sky130_fd_sc_hd__a21oi_1
XFILLER_47_180 VGND VGND VPWR VPWR sky130_fd_sc_hd__decap_3
XFILLER_39_169 VGND VGND VPWR VPWR sky130_fd_sc_hd__fill_2
X_2024_ _2024_/A _2028_/B VGND VGND VPWR VPWR _2024_/Y sky130_fd_sc_hd__nor2_1
Xhold210 _1967_/Y VGND VGND VPWR VPWR _2555_/D sky130_fd_sc_hd__dlygate4sd3_1
X_1808_ _2495_/Q _2487_/Q VGND VGND VPWR VPWR _1809_/C sky130_fd_sc_hd__nor2b_1
Xhold243 _1889_/Y VGND VGND VPWR VPWR _2529_/D sky130_fd_sc_hd__dlygate4sd3_1
Xhold232 _2534_/Q VGND VGND VPWR VPWR _1903_/A sky130_fd_sc_hd__dlygate4sd3_1
Xhold287 _2602_/Q VGND VGND VPWR VPWR _2040_/A sky130_fd_sc_hd__dlygate4sd3_1
Xhold254 _1907_/Y VGND VGND VPWR VPWR _2535_/D sky130_fd_sc_hd__dlygate4sd3_1
Xhold265 _1844_/Y VGND VGND VPWR VPWR _2514_/D sky130_fd_sc_hd__dlygate4sd3_1
XFILLER_40_29 VGND VGND VPWR VPWR sky130_fd_sc_hd__fill_2
Xhold221 _2515_/Q VGND VGND VPWR VPWR _1846_/A sky130_fd_sc_hd__dlygate4sd3_1
XTAP_TAPCELL_ROW_20_248 VGND VPWR sky130_fd_sc_hd__tapvpwrvgnd_1
X_1739_ _2121_/A _1739_/B VGND VGND VPWR VPWR _1740_/B sky130_fd_sc_hd__nor2_1
Xhold276 _1985_/X VGND VGND VPWR VPWR _2565_/D sky130_fd_sc_hd__dlygate4sd3_1
Xhold298 _2582_/Q VGND VGND VPWR VPWR hold298/X sky130_fd_sc_hd__dlygate4sd3_1
XFILLER_5_246 VGND VGND VPWR VPWR sky130_fd_sc_hd__fill_1
XFILLER_5_202 VGND VGND VPWR VPWR sky130_fd_sc_hd__decap_12
XTAP_TAPCELL_ROW_11_204 VGND VPWR sky130_fd_sc_hd__tapvpwrvgnd_1
XFILLER_14_85 VGND VGND VPWR VPWR sky130_fd_sc_hd__fill_1
XFILLER_5_279 VGND VGND VPWR VPWR sky130_fd_sc_hd__fill_1
XFILLER_55_81 VGND VGND VPWR VPWR sky130_fd_sc_hd__decap_3
XFILLER_29_191 VGND VGND VPWR VPWR sky130_fd_sc_hd__decap_3
XTAP_TAPCELL_ROW_34_318 VGND VPWR sky130_fd_sc_hd__tapvpwrvgnd_1
X_1524_ _1486_/A _1523_/Y _1486_/Y VGND VGND VPWR VPWR _1524_/Y sky130_fd_sc_hd__a21oi_1
X_2573_ clkload7/A _2573_/D load_slew144/X VGND VGND VPWR VPWR _2573_/Q sky130_fd_sc_hd__dfrtp_1
X_1386_ _1391_/B _1431_/B VGND VGND VPWR VPWR _1386_/Y sky130_fd_sc_hd__nand2_1
X_1455_ _2167_/A _1455_/B VGND VGND VPWR VPWR _1455_/Y sky130_fd_sc_hd__nor2_1
XTAP_TAPCELL_ROW_65_476 VGND VPWR sky130_fd_sc_hd__tapvpwrvgnd_1
X_2007_ _1240_/Y _2042_/B _2006_/Y VGND VGND VPWR VPWR _2585_/D sky130_fd_sc_hd__a21oi_1
XFILLER_51_28 VGND VGND VPWR VPWR sky130_fd_sc_hd__decap_4
XFILLER_50_197 VGND VGND VPWR VPWR sky130_fd_sc_hd__decap_3
XFILLER_50_153 VGND VGND VPWR VPWR sky130_fd_sc_hd__decap_4
XFILLER_2_216 VGND VGND VPWR VPWR sky130_fd_sc_hd__fill_2
XFILLER_25_40 VGND VGND VPWR VPWR sky130_fd_sc_hd__fill_2
XFILLER_25_51 VGND VGND VPWR VPWR sky130_fd_sc_hd__decap_4
XFILLER_49_253 VGND VGND VPWR VPWR sky130_fd_sc_hd__decap_12
X_1240_ _2444_/Q VGND VGND VPWR VPWR _1240_/Y sky130_fd_sc_hd__inv_1
XTAP_TAPCELL_ROW_62_457 VGND VPWR sky130_fd_sc_hd__tapvpwrvgnd_1
XFILLER_32_197 VGND VGND VPWR VPWR sky130_fd_sc_hd__fill_2
X_2556_ _2607_/CLK _2556_/D _2494_/SET_B VGND VGND VPWR VPWR _2556_/Q sky130_fd_sc_hd__dfrtp_1
X_1507_ _1507_/A _1507_/B VGND VGND VPWR VPWR _1507_/Y sky130_fd_sc_hd__nor2_1
X_2487_ clkload9/A _2487_/D load_slew166/X VGND VGND VPWR VPWR _2487_/Q sky130_fd_sc_hd__dfrtp_1
X_2625_ _2633_/CLK _2625_/D _2429_/SET_B VGND VGND VPWR VPWR _2625_/Q sky130_fd_sc_hd__dfrtp_1
XFILLER_55_234 VGND VGND VPWR VPWR sky130_fd_sc_hd__decap_4
X_1438_ _2478_/Q _1423_/Y _1437_/X VGND VGND VPWR VPWR _1438_/Y sky130_fd_sc_hd__a21oi_1
X_1369_ _1363_/Y _1368_/X _2332_/A VGND VGND VPWR VPWR _1369_/Y sky130_fd_sc_hd__a21oi_1
XFILLER_62_16 VGND VGND VPWR VPWR sky130_fd_sc_hd__fill_2
XTAP_TAPCELL_ROW_53_413 VGND VPWR sky130_fd_sc_hd__tapvpwrvgnd_1
XFILLER_46_267 VGND VGND VPWR VPWR sky130_fd_sc_hd__decap_4
XFILLER_46_212 VGND VGND VPWR VPWR sky130_fd_sc_hd__fill_2
XFILLER_36_83 VGND VGND VPWR VPWR sky130_fd_sc_hd__fill_1
XFILLER_14_197 VGND VGND VPWR VPWR sky130_fd_sc_hd__fill_1
X_2410_ _2592_/CLK _2410_/D load_slew147/X VGND VGND VPWR VPWR _2410_/Q sky130_fd_sc_hd__dfrtp_1
X_2341_ _2331_/A _2351_/B _2340_/Y VGND VGND VPWR VPWR _2341_/Y sky130_fd_sc_hd__o21ai_0
X_1223_ _1223_/A VGND VGND VPWR VPWR _1539_/B sky130_fd_sc_hd__inv_1
X_2272_ _2272_/A _2272_/B VGND VGND VPWR VPWR _2290_/A sky130_fd_sc_hd__nor2_1
XFILLER_52_259 VGND VGND VPWR VPWR sky130_fd_sc_hd__fill_1
X_1987_ hold280/X _2392_/Q _2020_/B VGND VGND VPWR VPWR _2567_/D sky130_fd_sc_hd__mux2_1
XFILLER_20_145 VGND VGND VPWR VPWR sky130_fd_sc_hd__fill_2
XFILLER_20_189 VGND VGND VPWR VPWR sky130_fd_sc_hd__decap_4
X_2608_ clkload5/A _2608_/D fanout157/A VGND VGND VPWR VPWR _2608_/Q sky130_fd_sc_hd__dfstp_2
X_2539_ clkload5/A _2539_/D fanout155/X VGND VGND VPWR VPWR _2539_/Q sky130_fd_sc_hd__dfrtp_1
Xwire60 wire60/A VGND VGND VPWR VPWR wire60/X sky130_fd_sc_hd__clkdlybuf4s25_1
XFILLER_43_237 VGND VGND VPWR VPWR sky130_fd_sc_hd__decap_12
XFILLER_11_167 VGND VGND VPWR VPWR sky130_fd_sc_hd__fill_1
XFILLER_22_85 VGND VGND VPWR VPWR sky130_fd_sc_hd__fill_1
Xfanout191 fanout192/X VGND VGND VPWR VPWR fanout191/X sky130_fd_sc_hd__clkdlybuf4s50_1
Xfanout180 fanout182/X VGND VGND VPWR VPWR wire181/A sky130_fd_sc_hd__clkdlybuf4s50_1
XFILLER_19_245 VGND VGND VPWR VPWR sky130_fd_sc_hd__decap_3
X_1910_ _1975_/B _1908_/Y _1909_/Y VGND VGND VPWR VPWR _1910_/Y sky130_fd_sc_hd__o21ai_0
XTAP_TAPCELL_ROW_29_295 VGND VPWR sky130_fd_sc_hd__tapvpwrvgnd_1
X_1772_ _1999_/S _1770_/Y _1771_/Y VGND VGND VPWR VPWR _2490_/D sky130_fd_sc_hd__a21oi_1
X_1841_ _1951_/B _1839_/Y _1840_/Y VGND VGND VPWR VPWR _2513_/D sky130_fd_sc_hd__o21ai_0
XFILLER_6_171 VGND VGND VPWR VPWR sky130_fd_sc_hd__fill_2
XFILLER_8_21 VGND VGND VPWR VPWR sky130_fd_sc_hd__fill_1
X_2324_ _2316_/A _2351_/B _2360_/A VGND VGND VPWR VPWR _2324_/Y sky130_fd_sc_hd__o21ai_0
X_2186_ _2201_/C _2186_/B VGND VGND VPWR VPWR _2189_/A sky130_fd_sc_hd__xnor2_1
X_2255_ _2255_/A _2255_/B VGND VGND VPWR VPWR _2255_/Y sky130_fd_sc_hd__nor2_1
X_1206_ _2483_/Q VGND VGND VPWR VPWR _2289_/A sky130_fd_sc_hd__inv_1
XFILLER_31_229 VGND VGND VPWR VPWR sky130_fd_sc_hd__fill_1
XTAP_TAPCELL_ROW_3_163 VGND VPWR sky130_fd_sc_hd__tapvpwrvgnd_1
XFILLER_16_204 VGND VGND VPWR VPWR sky130_fd_sc_hd__fill_2
X_2040_ _2040_/A _2042_/B VGND VGND VPWR VPWR _2040_/Y sky130_fd_sc_hd__nor2_1
XFILLER_30_251 VGND VGND VPWR VPWR sky130_fd_sc_hd__fill_1
XFILLER_15_281 VGND VGND VPWR VPWR sky130_fd_sc_hd__decap_8
XTAP_TAPCELL_ROW_17_232 VGND VPWR sky130_fd_sc_hd__tapvpwrvgnd_1
X_1824_ _2633_/Q _1260_/Y _1823_/Y VGND VGND VPWR VPWR _2505_/D sky130_fd_sc_hd__o21ai_0
X_1686_ _1688_/B _1686_/B VGND VGND VPWR VPWR _1686_/Y sky130_fd_sc_hd__nand2_1
X_1755_ _2123_/B _1755_/B _1755_/C VGND VGND VPWR VPWR _1756_/B sky130_fd_sc_hd__nand3_1
XFILLER_57_104 VGND VGND VPWR VPWR sky130_fd_sc_hd__decap_4
X_2238_ _2283_/B _2236_/Y _2237_/Y VGND VGND VPWR VPWR _2238_/Y sky130_fd_sc_hd__a21oi_1
XFILLER_38_29 VGND VGND VPWR VPWR sky130_fd_sc_hd__fill_2
X_2307_ _2307_/A _2307_/B VGND VGND VPWR VPWR _2322_/A sky130_fd_sc_hd__xnor2_1
X_2169_ _2198_/B _2474_/Q VGND VGND VPWR VPWR _2171_/B sky130_fd_sc_hd__xor2_1
XTAP_TAPCELL_ROW_48_390 VGND VPWR sky130_fd_sc_hd__tapvpwrvgnd_1
XTAP_TAPCELL_ROW_0_144 VGND VPWR sky130_fd_sc_hd__tapvpwrvgnd_1
XFILLER_70_27 VGND VGND VPWR VPWR sky130_fd_sc_hd__fill_1
XFILLER_0_133 VGND VGND VPWR VPWR sky130_fd_sc_hd__decap_6
XFILLER_28_40 VGND VGND VPWR VPWR sky130_fd_sc_hd__decap_12
XFILLER_12_251 VGND VGND VPWR VPWR sky130_fd_sc_hd__fill_1
XFILLER_60_82 VGND VGND VPWR VPWR sky130_fd_sc_hd__fill_2
X_1540_ _2442_/Q _2167_/A _1561_/B VGND VGND VPWR VPWR _1540_/X sky130_fd_sc_hd__or3_1
X_1471_ _2242_/A _2230_/A _2255_/A _2230_/B VGND VGND VPWR VPWR _1472_/D sky130_fd_sc_hd__nor4_1
X_2023_ _1232_/Y _2028_/B _2022_/Y VGND VGND VPWR VPWR _2593_/D sky130_fd_sc_hd__a21oi_1
X_1807_ _1807_/A _1807_/B VGND VGND VPWR VPWR _2502_/D sky130_fd_sc_hd__xnor2_1
XPHY_EDGE_ROW_17_Left_88 VGND VGND VPWR VPWR sky130_fd_sc_hd__decap_3
XTAP_TAPCELL_ROW_20_249 VGND VPWR sky130_fd_sc_hd__tapvpwrvgnd_1
Xhold277 _2581_/Q VGND VGND VPWR VPWR hold277/X sky130_fd_sc_hd__dlygate4sd3_1
Xhold200 _2532_/Q VGND VGND VPWR VPWR _1897_/A sky130_fd_sc_hd__dlygate4sd3_1
XFILLER_49_39 VGND VGND VPWR VPWR sky130_fd_sc_hd__decap_12
Xhold233 _1904_/Y VGND VGND VPWR VPWR _2534_/D sky130_fd_sc_hd__dlygate4sd3_1
Xhold244 _2527_/Q VGND VGND VPWR VPWR _1882_/A sky130_fd_sc_hd__dlygate4sd3_1
Xhold288 _2576_/Q VGND VGND VPWR VPWR hold288/X sky130_fd_sc_hd__dlygate4sd3_1
Xhold255 _2536_/Q VGND VGND VPWR VPWR _1909_/A sky130_fd_sc_hd__dlygate4sd3_1
Xhold211 _2525_/Q VGND VGND VPWR VPWR _1876_/A sky130_fd_sc_hd__dlygate4sd3_1
Xhold222 _2544_/Q VGND VGND VPWR VPWR _1933_/A sky130_fd_sc_hd__dlygate4sd3_1
X_1669_ _2483_/Q _2274_/A _1697_/B VGND VGND VPWR VPWR _1702_/B sky130_fd_sc_hd__nand3_1
Xhold266 _2548_/Q VGND VGND VPWR VPWR _1945_/A sky130_fd_sc_hd__dlygate4sd3_1
X_1738_ _2457_/Q _2399_/Q _2456_/Q _2398_/Q VGND VGND VPWR VPWR _1739_/B sky130_fd_sc_hd__o22ai_1
Xhold299 _2590_/Q VGND VGND VPWR VPWR _2016_/A sky130_fd_sc_hd__dlygate4sd3_1
XFILLER_30_63 VGND VGND VPWR VPWR sky130_fd_sc_hd__fill_2
XFILLER_5_214 VGND VGND VPWR VPWR sky130_fd_sc_hd__fill_2
XTAP_TAPCELL_ROW_11_205 VGND VPWR sky130_fd_sc_hd__tapvpwrvgnd_1
XFILLER_30_85 VGND VGND VPWR VPWR sky130_fd_sc_hd__decap_3
XTAP_TAPCELL_ROW_34_319 VGND VPWR sky130_fd_sc_hd__tapvpwrvgnd_1
X_1523_ _1523_/A _1523_/B VGND VGND VPWR VPWR _1523_/Y sky130_fd_sc_hd__nor2_1
X_2572_ clkload1/A _2572_/D load_slew144/X VGND VGND VPWR VPWR _2572_/Q sky130_fd_sc_hd__dfrtp_1
X_1454_ _1414_/Y _1451_/Y _1452_/Y _1470_/B VGND VGND VPWR VPWR _1454_/X sky130_fd_sc_hd__a211o_1
XFILLER_67_221 VGND VGND VPWR VPWR sky130_fd_sc_hd__decap_3
XFILLER_67_210 VGND VGND VPWR VPWR sky130_fd_sc_hd__decap_3
X_1385_ _2213_/B _1389_/B VGND VGND VPWR VPWR _1429_/A sky130_fd_sc_hd__xor2_1
XFILLER_50_165 VGND VGND VPWR VPWR sky130_fd_sc_hd__fill_1
X_2006_ _2006_/A _2010_/B VGND VGND VPWR VPWR _2006_/Y sky130_fd_sc_hd__nor2_1
XFILLER_25_63 VGND VGND VPWR VPWR sky130_fd_sc_hd__decap_4
XFILLER_41_51 VGND VGND VPWR VPWR sky130_fd_sc_hd__decap_4
XFILLER_66_70 VGND VGND VPWR VPWR sky130_fd_sc_hd__decap_8
XFILLER_49_265 VGND VGND VPWR VPWR sky130_fd_sc_hd__decap_8
XFILLER_64_257 VGND VGND VPWR VPWR sky130_fd_sc_hd__decap_4
XTAP_TAPCELL_ROW_62_458 VGND VPWR sky130_fd_sc_hd__tapvpwrvgnd_1
XFILLER_32_121 VGND VGND VPWR VPWR sky130_fd_sc_hd__decap_3
XFILLER_17_162 VGND VGND VPWR VPWR sky130_fd_sc_hd__decap_6
X_2624_ _2633_/CLK _2624_/D fanout183/A VGND VGND VPWR VPWR _2624_/Q sky130_fd_sc_hd__dfrtp_1
XTAP_TAPCELL_ROW_30_300 VGND VPWR sky130_fd_sc_hd__tapvpwrvgnd_1
X_2555_ _2634_/CLK _2555_/D fanout182/X VGND VGND VPWR VPWR _2555_/Q sky130_fd_sc_hd__dfrtp_1
X_1506_ _1477_/A _1477_/B _1303_/A VGND VGND VPWR VPWR _1507_/B sky130_fd_sc_hd__a21oi_1
X_1437_ _2477_/Q _1437_/B _1437_/C VGND VGND VPWR VPWR _1437_/X sky130_fd_sc_hd__maj3_1
XPHY_EDGE_ROW_34_Left_105 VGND VGND VPWR VPWR sky130_fd_sc_hd__decap_3
X_2486_ clkload4/A _2486_/D _2437_/SET_B VGND VGND VPWR VPWR _2486_/Q sky130_fd_sc_hd__dfrtp_1
XFILLER_55_279 VGND VGND VPWR VPWR sky130_fd_sc_hd__fill_1
XFILLER_55_202 VGND VGND VPWR VPWR sky130_fd_sc_hd__decap_3
XTAP_TAPCELL_ROW_53_414 VGND VPWR sky130_fd_sc_hd__tapvpwrvgnd_1
X_1299_ _2255_/A _2242_/B VGND VGND VPWR VPWR _1299_/Y sky130_fd_sc_hd__nor2_1
Xmax_cap19 _2052_/B VGND VGND VPWR VPWR _2080_/B sky130_fd_sc_hd__buf_1
X_1368_ _2318_/A _1368_/B VGND VGND VPWR VPWR _1368_/X sky130_fd_sc_hd__or2_0
XPHY_EDGE_ROW_43_Left_114 VGND VGND VPWR VPWR sky130_fd_sc_hd__decap_3
XPHY_EDGE_ROW_52_Left_123 VGND VGND VPWR VPWR sky130_fd_sc_hd__decap_3
XPHY_EDGE_ROW_61_Left_132 VGND VGND VPWR VPWR sky130_fd_sc_hd__decap_3
XPHY_EDGE_ROW_70_Left_141 VGND VGND VPWR VPWR sky130_fd_sc_hd__decap_3
XFILLER_52_83 VGND VGND VPWR VPWR sky130_fd_sc_hd__fill_1
X_2271_ _2232_/A _2255_/B _2270_/Y VGND VGND VPWR VPWR _2271_/Y sky130_fd_sc_hd__a21oi_1
X_2340_ _2351_/B _2339_/X _1557_/A VGND VGND VPWR VPWR _2340_/Y sky130_fd_sc_hd__a21oi_1
X_1222_ _1222_/A VGND VGND VPWR VPWR _2634_/D sky130_fd_sc_hd__inv_1
XFILLER_37_279 VGND VGND VPWR VPWR sky130_fd_sc_hd__fill_1
XFILLER_52_227 VGND VGND VPWR VPWR sky130_fd_sc_hd__fill_1
XFILLER_20_113 VGND VGND VPWR VPWR sky130_fd_sc_hd__decap_8
X_1986_ hold269/X _2391_/Q _2034_/B VGND VGND VPWR VPWR _1986_/X sky130_fd_sc_hd__mux2_1
X_2607_ _2607_/CLK _2607_/D fanout187/A VGND VGND VPWR VPWR _2607_/Q sky130_fd_sc_hd__dfrtp_1
Xclkbuf_leaf_9_clk clkbuf_leaf_9_clk/A VGND VGND VPWR VPWR clkload3/A sky130_fd_sc_hd__clkbuf_16
X_2538_ clkload5/A _2538_/D fanout155/X VGND VGND VPWR VPWR _2538_/Q sky130_fd_sc_hd__dfrtp_1
X_2469_ clkload5/A _2469_/D load_slew154/X VGND VGND VPWR VPWR _2469_/Q sky130_fd_sc_hd__dfrtp_1
XFILLER_43_249 VGND VGND VPWR VPWR sky130_fd_sc_hd__decap_12
XFILLER_43_205 VGND VGND VPWR VPWR sky130_fd_sc_hd__decap_8
Xwire72 wire72/A VGND VGND VPWR VPWR mute sky130_fd_sc_hd__clkbuf_4
XFILLER_28_257 VGND VGND VPWR VPWR sky130_fd_sc_hd__fill_2
XFILLER_11_179 VGND VGND VPWR VPWR sky130_fd_sc_hd__decap_3
XFILLER_22_53 VGND VGND VPWR VPWR sky130_fd_sc_hd__decap_6
XPHY_EDGE_ROW_5_Left_76 VGND VGND VPWR VPWR sky130_fd_sc_hd__decap_3
Xfanout192 input1/X VGND VGND VPWR VPWR fanout192/X sky130_fd_sc_hd__clkdlybuf4s50_1
XFILLER_63_71 VGND VGND VPWR VPWR sky130_fd_sc_hd__fill_2
X_1840_ _1840_/A _1909_/B VGND VGND VPWR VPWR _1840_/Y sky130_fd_sc_hd__nand2_1
XTAP_TAPCELL_ROW_29_296 VGND VPWR sky130_fd_sc_hd__tapvpwrvgnd_1
X_1771_ _1771_/A _1999_/S VGND VGND VPWR VPWR _1771_/Y sky130_fd_sc_hd__nor2_1
X_2254_ _2136_/Y _2253_/Y _2241_/B _2254_/B2 VGND VGND VPWR VPWR _2429_/D sky130_fd_sc_hd__a2bb2oi_1
XFILLER_40_3 VGND VGND VPWR VPWR sky130_fd_sc_hd__decap_12
X_2323_ _2323_/A _2323_/B VGND VGND VPWR VPWR _2323_/Y sky130_fd_sc_hd__xnor2_1
X_2185_ _2201_/A _2185_/B VGND VGND VPWR VPWR _2186_/B sky130_fd_sc_hd__xnor2_1
XFILLER_40_208 VGND VGND VPWR VPWR sky130_fd_sc_hd__fill_1
X_1205_ _2484_/Q VGND VGND VPWR VPWR _2307_/A sky130_fd_sc_hd__inv_1
XFILLER_25_216 VGND VGND VPWR VPWR sky130_fd_sc_hd__decap_8
X_1969_ _1969_/A _1969_/B VGND VGND VPWR VPWR _1969_/Y sky130_fd_sc_hd__nand2_1
XTAP_TAPCELL_ROW_3_164 VGND VPWR sky130_fd_sc_hd__tapvpwrvgnd_1
XFILLER_16_216 VGND VGND VPWR VPWR sky130_fd_sc_hd__decap_4
XTAP_TAPCELL_ROW_26_277 VGND VPWR sky130_fd_sc_hd__tapvpwrvgnd_1
XFILLER_3_120 VGND VGND VPWR VPWR sky130_fd_sc_hd__fill_1
XFILLER_3_175 VGND VGND VPWR VPWR sky130_fd_sc_hd__fill_2
XTAP_TAPCELL_ROW_17_233 VGND VPWR sky130_fd_sc_hd__tapvpwrvgnd_1
X_1823_ _2633_/Q _1975_/A _1833_/A VGND VGND VPWR VPWR _1823_/Y sky130_fd_sc_hd__nand3_1
XFILLER_30_274 VGND VGND VPWR VPWR sky130_fd_sc_hd__fill_1
X_1754_ _2119_/A _1754_/B VGND VGND VPWR VPWR _1757_/A sky130_fd_sc_hd__or2_0
X_1685_ _2200_/A _1685_/B VGND VGND VPWR VPWR _1686_/B sky130_fd_sc_hd__nand2_1
X_2237_ _2230_/B _2283_/B _1256_/Y VGND VGND VPWR VPWR _2237_/Y sky130_fd_sc_hd__o21ai_0
X_2306_ _2484_/Q _2307_/B VGND VGND VPWR VPWR _2306_/Y sky130_fd_sc_hd__nand2_1
XFILLER_54_29 VGND VGND VPWR VPWR sky130_fd_sc_hd__fill_2
XTAP_TAPCELL_ROW_48_391 VGND VPWR sky130_fd_sc_hd__tapvpwrvgnd_1
X_2099_ _2114_/C _2102_/D _2414_/Q VGND VGND VPWR VPWR _2099_/Y sky130_fd_sc_hd__o21ai_0
XTAP_TAPCELL_ROW_0_145 VGND VPWR sky130_fd_sc_hd__tapvpwrvgnd_1
X_2168_ _2168_/A _2168_/B VGND VGND VPWR VPWR _2297_/A sky130_fd_sc_hd__nand2_1
XFILLER_13_219 VGND VGND VPWR VPWR sky130_fd_sc_hd__fill_1
XPHY_EDGE_ROW_17_Right_17 VGND VGND VPWR VPWR sky130_fd_sc_hd__decap_3
XFILLER_0_167 VGND VGND VPWR VPWR sky130_fd_sc_hd__fill_1
XPHY_EDGE_ROW_26_Right_26 VGND VGND VPWR VPWR sky130_fd_sc_hd__decap_3
XFILLER_28_52 VGND VGND VPWR VPWR sky130_fd_sc_hd__decap_4
XFILLER_28_85 VGND VGND VPWR VPWR sky130_fd_sc_hd__decap_3
XPHY_EDGE_ROW_35_Right_35 VGND VGND VPWR VPWR sky130_fd_sc_hd__decap_3
XFILLER_60_94 VGND VGND VPWR VPWR sky130_fd_sc_hd__decap_4
XFILLER_8_278 VGND VGND VPWR VPWR sky130_fd_sc_hd__decap_8
X_1470_ _2351_/A _1470_/B _1470_/C VGND VGND VPWR VPWR _1472_/C sky130_fd_sc_hd__nor3_1
XPHY_EDGE_ROW_44_Right_44 VGND VGND VPWR VPWR sky130_fd_sc_hd__decap_3
XPHY_EDGE_ROW_53_Right_53 VGND VGND VPWR VPWR sky130_fd_sc_hd__decap_3
XFILLER_47_193 VGND VGND VPWR VPWR sky130_fd_sc_hd__fill_2
XTAP_TAPCELL_ROW_45_372 VGND VPWR sky130_fd_sc_hd__tapvpwrvgnd_1
X_2022_ _2022_/A _2028_/B VGND VGND VPWR VPWR _2022_/Y sky130_fd_sc_hd__nor2_1
X_1806_ _1806_/A _1806_/B VGND VGND VPWR VPWR _2501_/D sky130_fd_sc_hd__xnor2_1
Xhold201 _1898_/Y VGND VGND VPWR VPWR _2532_/D sky130_fd_sc_hd__dlygate4sd3_1
XPHY_EDGE_ROW_62_Right_62 VGND VGND VPWR VPWR sky130_fd_sc_hd__decap_3
Xhold212 _2528_/Q VGND VGND VPWR VPWR _1885_/A sky130_fd_sc_hd__dlygate4sd3_1
Xhold289 _2561_/Q VGND VGND VPWR VPWR hold289/X sky130_fd_sc_hd__dlygate4sd3_1
Xhold245 _1883_/Y VGND VGND VPWR VPWR _2527_/D sky130_fd_sc_hd__dlygate4sd3_1
Xhold256 _1910_/Y VGND VGND VPWR VPWR _2536_/D sky130_fd_sc_hd__dlygate4sd3_1
X_1599_ _1603_/A _1600_/B _1599_/C VGND VGND VPWR VPWR _2630_/D sky130_fd_sc_hd__nor3_1
Xhold223 _1934_/Y VGND VGND VPWR VPWR _2544_/D sky130_fd_sc_hd__dlygate4sd3_1
Xhold278 _2572_/Q VGND VGND VPWR VPWR hold278/X sky130_fd_sc_hd__dlygate4sd3_1
X_1668_ _2274_/A _1697_/B VGND VGND VPWR VPWR _1699_/B sky130_fd_sc_hd__nand2_1
Xhold267 _1946_/Y VGND VGND VPWR VPWR _2548_/D sky130_fd_sc_hd__dlygate4sd3_1
Xhold234 _2517_/Q VGND VGND VPWR VPWR _1852_/A sky130_fd_sc_hd__dlygate4sd3_1
X_1737_ _2458_/Q _2400_/Q _2457_/Q _2399_/Q VGND VGND VPWR VPWR _1740_/A sky130_fd_sc_hd__a22oi_1
Xload_slew170 fanout169/X VGND VGND VPWR VPWR load_slew170/X sky130_fd_sc_hd__buf_2
XFILLER_38_182 VGND VGND VPWR VPWR sky130_fd_sc_hd__decap_4
XTAP_TAPCELL_ROW_11_206 VGND VPWR sky130_fd_sc_hd__tapvpwrvgnd_1
XFILLER_14_65 VGND VGND VPWR VPWR sky130_fd_sc_hd__decap_8
XFILLER_30_97 VGND VGND VPWR VPWR sky130_fd_sc_hd__fill_1
XTAP_TAPCELL_ROW_59_442 VGND VPWR sky130_fd_sc_hd__tapvpwrvgnd_1
XFILLER_39_84 VGND VGND VPWR VPWR sky130_fd_sc_hd__fill_2
X_1522_ _1523_/A _1515_/Y _2625_/Q VGND VGND VPWR VPWR _1522_/Y sky130_fd_sc_hd__o21ai_0
X_2571_ clkload1/A _2571_/D fanout145/X VGND VGND VPWR VPWR _2571_/Q sky130_fd_sc_hd__dfrtp_1
X_1453_ _1414_/Y _1451_/Y _1452_/Y _1470_/B VGND VGND VPWR VPWR _1455_/B sky130_fd_sc_hd__a211oi_2
XFILLER_67_277 VGND VGND VPWR VPWR sky130_fd_sc_hd__decap_3
X_2005_ _1241_/Y _2010_/B _2004_/Y VGND VGND VPWR VPWR _2584_/D sky130_fd_sc_hd__a21oi_1
X_1384_ _2283_/A _2242_/B VGND VGND VPWR VPWR _1423_/A sky130_fd_sc_hd__xor2_1
XFILLER_35_196 VGND VGND VPWR VPWR sky130_fd_sc_hd__fill_1
XFILLER_26_141 VGND VGND VPWR VPWR sky130_fd_sc_hd__decap_6
XFILLER_41_166 VGND VGND VPWR VPWR sky130_fd_sc_hd__fill_2
XFILLER_41_155 VGND VGND VPWR VPWR sky130_fd_sc_hd__decap_8
XFILLER_66_82 VGND VGND VPWR VPWR sky130_fd_sc_hd__fill_2
XFILLER_49_288 VGND VGND VPWR VPWR sky130_fd_sc_hd__fill_1
XTAP_TAPCELL_ROW_62_459 VGND VPWR sky130_fd_sc_hd__tapvpwrvgnd_1
XTAP_TAPCELL_ROW_30_301 VGND VPWR sky130_fd_sc_hd__tapvpwrvgnd_1
XFILLER_17_141 VGND VGND VPWR VPWR sky130_fd_sc_hd__fill_1
X_2554_ _2634_/CLK _2554_/D load_slew177/X VGND VGND VPWR VPWR _2554_/Q sky130_fd_sc_hd__dfrtp_1
X_2623_ _2633_/CLK _2623_/D fanout183/A VGND VGND VPWR VPWR _2623_/Q sky130_fd_sc_hd__dfrtp_1
X_1505_ _2621_/Q _1503_/Y _1504_/X VGND VGND VPWR VPWR _1505_/Y sky130_fd_sc_hd__a21oi_1
X_1436_ _2476_/Q _1436_/B _1436_/C VGND VGND VPWR VPWR _1437_/C sky130_fd_sc_hd__maj3_1
X_2485_ clkload4/A _2485_/D fanout159/A VGND VGND VPWR VPWR _2485_/Q sky130_fd_sc_hd__dfrtp_1
X_1367_ _1350_/X _1356_/X _1363_/Y _2332_/A _1365_/X VGND VGND VPWR VPWR _1374_/A
+ sky130_fd_sc_hd__a221o_1
XFILLER_55_247 VGND VGND VPWR VPWR sky130_fd_sc_hd__decap_12
XFILLER_55_225 VGND VGND VPWR VPWR sky130_fd_sc_hd__fill_2
XTAP_TAPCELL_ROW_53_415 VGND VPWR sky130_fd_sc_hd__tapvpwrvgnd_1
X_1298_ _2255_/A _2242_/B VGND VGND VPWR VPWR _1298_/Y sky130_fd_sc_hd__nand2_1
XFILLER_62_29 VGND VGND VPWR VPWR sky130_fd_sc_hd__fill_1
X_2270_ _2283_/A _2255_/B _2173_/A VGND VGND VPWR VPWR _2270_/Y sky130_fd_sc_hd__o21ai_0
XTAP_TAPCELL_ROW_9_192 VGND VPWR sky130_fd_sc_hd__tapvpwrvgnd_1
X_1221_ _2442_/Q VGND VGND VPWR VPWR _1221_/Y sky130_fd_sc_hd__inv_1
XFILLER_37_214 VGND VGND VPWR VPWR sky130_fd_sc_hd__decap_3
XFILLER_20_158 VGND VGND VPWR VPWR sky130_fd_sc_hd__fill_2
X_1985_ hold275/X _2390_/Q _2034_/B VGND VGND VPWR VPWR _1985_/X sky130_fd_sc_hd__mux2_1
X_2606_ _2606_/CLK _2606_/D wire181/X VGND VGND VPWR VPWR _2606_/Q sky130_fd_sc_hd__dfrtp_1
X_2537_ clkload5/A _2537_/D load_slew162/X VGND VGND VPWR VPWR _2537_/Q sky130_fd_sc_hd__dfrtp_1
XPHY_EDGE_ROW_21_Left_92 VGND VGND VPWR VPWR sky130_fd_sc_hd__decap_3
XFILLER_57_18 VGND VGND VPWR VPWR sky130_fd_sc_hd__fill_1
X_2468_ _2592_/CLK _2468_/D load_slew154/X VGND VGND VPWR VPWR _2468_/Q sky130_fd_sc_hd__dfrtp_1
X_2399_ clkload1/A _2399_/D load_slew150/X VGND VGND VPWR VPWR _2399_/Q sky130_fd_sc_hd__dfrtp_1
X_1419_ _2289_/A _1419_/B VGND VGND VPWR VPWR _1419_/Y sky130_fd_sc_hd__nor2_1
XFILLER_51_250 VGND VGND VPWR VPWR sky130_fd_sc_hd__decap_8
XFILLER_7_129 VGND VGND VPWR VPWR sky130_fd_sc_hd__fill_1
XFILLER_11_169 VGND VGND VPWR VPWR sky130_fd_sc_hd__decap_4
XFILLER_0_3 VGND VGND VPWR VPWR sky130_fd_sc_hd__decap_12
Xfanout182 fanout191/X VGND VGND VPWR VPWR fanout182/X sky130_fd_sc_hd__clkdlybuf4s50_1
Xfanout171 fanout173/X VGND VGND VPWR VPWR fanout171/X sky130_fd_sc_hd__clkdlybuf4s50_1
XFILLER_34_228 VGND VGND VPWR VPWR sky130_fd_sc_hd__decap_4
XFILLER_19_203 VGND VGND VPWR VPWR sky130_fd_sc_hd__decap_12
XFILLER_19_225 VGND VGND VPWR VPWR sky130_fd_sc_hd__decap_12
XFILLER_63_61 VGND VGND VPWR VPWR sky130_fd_sc_hd__fill_2
X_1770_ _1770_/A _1770_/B VGND VGND VPWR VPWR _1770_/Y sky130_fd_sc_hd__xnor2_1
XFILLER_42_261 VGND VGND VPWR VPWR sky130_fd_sc_hd__fill_1
XFILLER_8_67 VGND VGND VPWR VPWR sky130_fd_sc_hd__fill_1
XFILLER_6_195 VGND VGND VPWR VPWR sky130_fd_sc_hd__fill_1
XFILLER_10_191 VGND VGND VPWR VPWR sky130_fd_sc_hd__decap_4
X_2184_ _1215_/Y _2286_/S _2183_/Y VGND VGND VPWR VPWR _2184_/Y sky130_fd_sc_hd__a21oi_1
X_2253_ _1256_/Y _2240_/Y _2251_/Y _2252_/Y VGND VGND VPWR VPWR _2253_/Y sky130_fd_sc_hd__o22ai_1
XFILLER_33_3 VGND VGND VPWR VPWR sky130_fd_sc_hd__fill_1
X_1204_ _2332_/A VGND VGND VPWR VPWR _2333_/A sky130_fd_sc_hd__inv_1
X_2322_ _2322_/A _2322_/B _2322_/C VGND VGND VPWR VPWR _2323_/B sky130_fd_sc_hd__maj3_1
X_1968_ _1966_/A _2581_/Q _1971_/S VGND VGND VPWR VPWR _1968_/Y sky130_fd_sc_hd__mux2i_1
X_1899_ _2532_/Q _2606_/Q _1902_/S VGND VGND VPWR VPWR _1899_/Y sky130_fd_sc_hd__mux2i_1
XTAP_TAPCELL_ROW_3_165 VGND VPWR sky130_fd_sc_hd__tapvpwrvgnd_1
XFILLER_16_239 VGND VGND VPWR VPWR sky130_fd_sc_hd__fill_1
XFILLER_17_65 VGND VGND VPWR VPWR sky130_fd_sc_hd__fill_1
XFILLER_24_250 VGND VGND VPWR VPWR sky130_fd_sc_hd__fill_2
XTAP_TAPCELL_ROW_26_278 VGND VPWR sky130_fd_sc_hd__tapvpwrvgnd_1
XTAP_TAPCELL_ROW_17_234 VGND VPWR sky130_fd_sc_hd__tapvpwrvgnd_1
X_1822_ _1822_/A _1831_/A VGND VGND VPWR VPWR _2504_/D sky130_fd_sc_hd__xor2_1
X_1753_ _2461_/Q _2403_/Q VGND VGND VPWR VPWR _1754_/B sky130_fd_sc_hd__and2_0
XFILLER_30_264 VGND VGND VPWR VPWR sky130_fd_sc_hd__fill_2
XFILLER_30_231 VGND VGND VPWR VPWR sky130_fd_sc_hd__decap_12
X_1684_ _1671_/Y _1683_/Y _2136_/A VGND VGND VPWR VPWR _2476_/D sky130_fd_sc_hd__a21oi_1
X_2236_ _2236_/A _2236_/B VGND VGND VPWR VPWR _2236_/Y sky130_fd_sc_hd__xnor2_1
X_2167_ _2167_/A _2168_/B VGND VGND VPWR VPWR _2167_/X sky130_fd_sc_hd__and2_0
X_2305_ _2351_/A _2305_/B VGND VGND VPWR VPWR _2307_/B sky130_fd_sc_hd__xnor2_1
XFILLER_70_29 VGND VGND VPWR VPWR sky130_fd_sc_hd__decap_12
XTAP_TAPCELL_ROW_0_146 VGND VPWR sky130_fd_sc_hd__tapvpwrvgnd_1
X_2098_ _2101_/A _2442_/Q _2167_/A _2098_/D VGND VGND VPWR VPWR _2108_/C sky130_fd_sc_hd__or4_1
XFILLER_21_231 VGND VGND VPWR VPWR sky130_fd_sc_hd__decap_8
XFILLER_0_113 VGND VGND VPWR VPWR sky130_fd_sc_hd__decap_12
XFILLER_56_161 VGND VGND VPWR VPWR sky130_fd_sc_hd__decap_8
XFILLER_47_172 VGND VGND VPWR VPWR sky130_fd_sc_hd__decap_8
XFILLER_39_106 VGND VGND VPWR VPWR sky130_fd_sc_hd__decap_6
X_2021_ _1233_/Y _2020_/B _2020_/Y VGND VGND VPWR VPWR _2592_/D sky130_fd_sc_hd__a21oi_1
XFILLER_62_131 VGND VGND VPWR VPWR sky130_fd_sc_hd__fill_1
XTAP_TAPCELL_ROW_45_373 VGND VPWR sky130_fd_sc_hd__tapvpwrvgnd_1
X_1805_ _2499_/Q _2500_/Q _2501_/Q _1805_/D VGND VGND VPWR VPWR _1807_/B sky130_fd_sc_hd__nand4_1
Xhold202 _2553_/Q VGND VGND VPWR VPWR _1960_/A sky130_fd_sc_hd__dlygate4sd3_1
Xhold213 _1886_/Y VGND VGND VPWR VPWR _2528_/D sky130_fd_sc_hd__dlygate4sd3_1
Xhold235 _2526_/Q VGND VGND VPWR VPWR _1879_/A sky130_fd_sc_hd__dlygate4sd3_1
Xhold224 _2520_/Q VGND VGND VPWR VPWR _1861_/A sky130_fd_sc_hd__dlygate4sd3_1
X_1736_ _2455_/Q _2397_/Q VGND VGND VPWR VPWR _2121_/B sky130_fd_sc_hd__nor2_1
Xhold246 _2557_/Q VGND VGND VPWR VPWR _1972_/A sky130_fd_sc_hd__dlygate4sd3_1
Xhold257 _2605_/Q VGND VGND VPWR VPWR _2046_/A sky130_fd_sc_hd__dlygate4sd3_1
X_1598_ _2630_/Q _1598_/B VGND VGND VPWR VPWR _1599_/C sky130_fd_sc_hd__nor2_1
Xhold268 _2519_/Q VGND VGND VPWR VPWR _1858_/A sky130_fd_sc_hd__dlygate4sd3_1
Xhold279 _1992_/X VGND VGND VPWR VPWR _2572_/D sky130_fd_sc_hd__dlygate4sd3_1
Xload_slew160 fanout159/X VGND VGND VPWR VPWR fanout157/A sky130_fd_sc_hd__buf_2
X_1667_ _2259_/A _1695_/B VGND VGND VPWR VPWR _1697_/B sky130_fd_sc_hd__nor2_1
XTAP_TAPCELL_ROW_68_487 VGND VPWR sky130_fd_sc_hd__tapvpwrvgnd_1
X_2219_ _2219_/A VGND VGND VPWR VPWR _2229_/A sky130_fd_sc_hd__inv_1
XFILLER_38_194 VGND VGND VPWR VPWR sky130_fd_sc_hd__fill_2
XFILLER_14_44 VGND VGND VPWR VPWR sky130_fd_sc_hd__fill_1
XTAP_TAPCELL_ROW_59_443 VGND VPWR sky130_fd_sc_hd__tapvpwrvgnd_1
XFILLER_39_74 VGND VGND VPWR VPWR sky130_fd_sc_hd__decap_6
XFILLER_29_183 VGND VGND VPWR VPWR sky130_fd_sc_hd__decap_3
X_2570_ clkload6/A _2570_/D fanout145/X VGND VGND VPWR VPWR _2570_/Q sky130_fd_sc_hd__dfrtp_1
X_1383_ _2283_/A _2242_/B VGND VGND VPWR VPWR _1383_/Y sky130_fd_sc_hd__nor2_1
X_1521_ _2626_/Q _1521_/B VGND VGND VPWR VPWR _1521_/Y sky130_fd_sc_hd__nand2_1
X_1452_ _1352_/Y _1415_/A _1414_/B _2332_/A VGND VGND VPWR VPWR _1452_/Y sky130_fd_sc_hd__o22ai_1
X_2004_ _2004_/A _2010_/B VGND VGND VPWR VPWR _2004_/Y sky130_fd_sc_hd__nor2_1
XFILLER_50_178 VGND VGND VPWR VPWR sky130_fd_sc_hd__decap_12
X_1719_ _2446_/Q _2388_/Q _2445_/Q _2387_/Q VGND VGND VPWR VPWR _1719_/Y sky130_fd_sc_hd__a22oi_1
XFILLER_58_223 VGND VGND VPWR VPWR sky130_fd_sc_hd__decap_3
XFILLER_41_101 VGND VGND VPWR VPWR sky130_fd_sc_hd__fill_2
XFILLER_25_32 VGND VGND VPWR VPWR sky130_fd_sc_hd__decap_8
XFILLER_26_175 VGND VGND VPWR VPWR sky130_fd_sc_hd__fill_2
XFILLER_26_197 VGND VGND VPWR VPWR sky130_fd_sc_hd__decap_3
XFILLER_41_178 VGND VGND VPWR VPWR sky130_fd_sc_hd__decap_12
XFILLER_49_223 VGND VGND VPWR VPWR sky130_fd_sc_hd__fill_1
XFILLER_2_25 VGND VGND VPWR VPWR sky130_fd_sc_hd__decap_3
XFILLER_66_50 VGND VGND VPWR VPWR sky130_fd_sc_hd__decap_4
XFILLER_17_175 VGND VGND VPWR VPWR sky130_fd_sc_hd__decap_4
X_2553_ _2634_/CLK _2553_/D load_slew177/X VGND VGND VPWR VPWR _2553_/Q sky130_fd_sc_hd__dfrtp_1
X_1504_ _2620_/Q _1504_/B _1504_/C VGND VGND VPWR VPWR _1504_/X sky130_fd_sc_hd__maj3_1
X_2622_ _2633_/CLK _2622_/D fanout183/A VGND VGND VPWR VPWR _2622_/Q sky130_fd_sc_hd__dfrtp_1
X_1435_ _2475_/Q _1435_/B _1435_/C VGND VGND VPWR VPWR _1436_/C sky130_fd_sc_hd__maj3_1
X_2484_ clkload4/A _2484_/D fanout159/A VGND VGND VPWR VPWR _2484_/Q sky130_fd_sc_hd__dfrtp_1
X_1366_ _1350_/X _1356_/X _1363_/Y _2332_/A _1365_/X VGND VGND VPWR VPWR wire29/A
+ sky130_fd_sc_hd__a221oi_1
X_1297_ _1289_/X _1290_/Y _2475_/Q VGND VGND VPWR VPWR _1297_/Y sky130_fd_sc_hd__o21ai_0
XFILLER_55_259 VGND VGND VPWR VPWR sky130_fd_sc_hd__decap_8
XTAP_TAPCELL_ROW_53_416 VGND VPWR sky130_fd_sc_hd__tapvpwrvgnd_1
XFILLER_46_237 VGND VGND VPWR VPWR sky130_fd_sc_hd__decap_3
XFILLER_46_204 VGND VGND VPWR VPWR sky130_fd_sc_hd__decap_8
XFILLER_14_145 VGND VGND VPWR VPWR sky130_fd_sc_hd__decap_6
X_1220_ _2411_/Q VGND VGND VPWR VPWR _1262_/C sky130_fd_sc_hd__inv_1
XTAP_TAPCELL_ROW_9_193 VGND VPWR sky130_fd_sc_hd__tapvpwrvgnd_1
XFILLER_60_240 VGND VGND VPWR VPWR sky130_fd_sc_hd__fill_1
XFILLER_45_270 VGND VGND VPWR VPWR sky130_fd_sc_hd__decap_3
XFILLER_60_273 VGND VGND VPWR VPWR sky130_fd_sc_hd__decap_8
X_1984_ hold261/X _2389_/Q _2034_/B VGND VGND VPWR VPWR _2564_/D sky130_fd_sc_hd__mux2_1
XFILLER_9_182 VGND VGND VPWR VPWR sky130_fd_sc_hd__fill_1
X_2605_ _2606_/CLK _2605_/D wire181/X VGND VGND VPWR VPWR _2605_/Q sky130_fd_sc_hd__dfrtp_1
X_2536_ clkload8/A _2536_/D _2429_/SET_B VGND VGND VPWR VPWR _2536_/Q sky130_fd_sc_hd__dfrtp_1
X_2467_ clkload5/A _2467_/D load_slew154/X VGND VGND VPWR VPWR _2467_/Q sky130_fd_sc_hd__dfrtp_1
X_1349_ _1334_/Y _1338_/Y _1348_/Y VGND VGND VPWR VPWR _1349_/Y sky130_fd_sc_hd__a21oi_1
X_2398_ clkload1/A _2398_/D load_slew144/X VGND VGND VPWR VPWR _2398_/Q sky130_fd_sc_hd__dfrtp_1
X_1418_ _1418_/A _1418_/B VGND VGND VPWR VPWR _1419_/B sky130_fd_sc_hd__xnor2_1
XFILLER_7_119 VGND VGND VPWR VPWR sky130_fd_sc_hd__fill_1
Xfanout183 fanout183/A VGND VGND VPWR VPWR fanout183/X sky130_fd_sc_hd__clkdlybuf4s50_1
Xfanout161 fanout163/X VGND VGND VPWR VPWR fanout161/X sky130_fd_sc_hd__clkdlybuf4s50_1
XFILLER_63_51 VGND VGND VPWR VPWR sky130_fd_sc_hd__fill_2
XFILLER_19_237 VGND VGND VPWR VPWR sky130_fd_sc_hd__decap_8
XFILLER_6_141 VGND VGND VPWR VPWR sky130_fd_sc_hd__fill_2
X_2321_ _2321_/A _2320_/Y VGND VGND VPWR VPWR _2323_/A sky130_fd_sc_hd__nor2b_1
XFILLER_10_181 VGND VGND VPWR VPWR sky130_fd_sc_hd__fill_2
X_2183_ _1389_/B _2286_/S _2365_/B1 VGND VGND VPWR VPWR _2183_/Y sky130_fd_sc_hd__o21ai_0
X_2252_ _2198_/A _2283_/B _1256_/Y VGND VGND VPWR VPWR _2252_/Y sky130_fd_sc_hd__o21ai_0
X_1203_ _2331_/B VGND VGND VPWR VPWR _2330_/B sky130_fd_sc_hd__inv_1
XFILLER_26_3 VGND VGND VPWR VPWR sky130_fd_sc_hd__decap_8
X_1967_ _1966_/B _1965_/Y _1966_/Y VGND VGND VPWR VPWR _1967_/Y sky130_fd_sc_hd__o21ai_0
X_1898_ _1969_/B _1896_/Y _1897_/Y VGND VGND VPWR VPWR _1898_/Y sky130_fd_sc_hd__o21ai_0
X_2519_ _2592_/CLK _2519_/D load_slew147/X VGND VGND VPWR VPWR _2519_/Q sky130_fd_sc_hd__dfrtp_1
XTAP_TAPCELL_ROW_3_166 VGND VPWR sky130_fd_sc_hd__tapvpwrvgnd_1
XFILLER_17_44 VGND VGND VPWR VPWR sky130_fd_sc_hd__decap_3
XFILLER_17_88 VGND VGND VPWR VPWR sky130_fd_sc_hd__fill_1
XPHY_EDGE_ROW_49_Left_120 VGND VGND VPWR VPWR sky130_fd_sc_hd__decap_3
XFILLER_33_65 VGND VGND VPWR VPWR sky130_fd_sc_hd__fill_2
XTAP_TAPCELL_ROW_26_279 VGND VPWR sky130_fd_sc_hd__tapvpwrvgnd_1
XFILLER_15_240 VGND VGND VPWR VPWR sky130_fd_sc_hd__decap_8
XTAP_TAPCELL_ROW_17_235 VGND VPWR sky130_fd_sc_hd__tapvpwrvgnd_1
X_1821_ _1833_/A _1829_/B VGND VGND VPWR VPWR _1831_/A sky130_fd_sc_hd__nor2_1
Xmax_cap103 _2504_/Q VGND VGND VPWR VPWR i2s_ws sky130_fd_sc_hd__buf_4
X_1752_ _2461_/Q _2403_/Q VGND VGND VPWR VPWR _1752_/X sky130_fd_sc_hd__or2_0
X_1683_ _1685_/B _1683_/B VGND VGND VPWR VPWR _1683_/Y sky130_fd_sc_hd__nand2_1
XFILLER_30_243 VGND VGND VPWR VPWR sky130_fd_sc_hd__decap_4
Xclkbuf_leaf_10_clk clkbuf_leaf_9_clk/A VGND VGND VPWR VPWR clkload4/A sky130_fd_sc_hd__clkbuf_16
X_2304_ _2351_/A _2305_/B VGND VGND VPWR VPWR _2304_/Y sky130_fd_sc_hd__nand2b_1
X_2166_ _1216_/Y _2255_/B _2165_/Y VGND VGND VPWR VPWR _2166_/Y sky130_fd_sc_hd__a21oi_1
XFILLER_65_173 VGND VGND VPWR VPWR sky130_fd_sc_hd__fill_1
X_2235_ _2235_/A _2234_/X VGND VGND VPWR VPWR _2236_/B sky130_fd_sc_hd__nor2b_1
XTAP_TAPCELL_ROW_0_147 VGND VPWR sky130_fd_sc_hd__tapvpwrvgnd_1
X_2097_ _2101_/A _2442_/Q _2167_/A _2098_/D VGND VGND VPWR VPWR wire16/A sky130_fd_sc_hd__nor4_2
XPHY_EDGE_ROW_3_Right_3 VGND VGND VPWR VPWR sky130_fd_sc_hd__decap_3
Xclkbuf_1_1__f_clk clkbuf_0_clk/X VGND VGND VPWR VPWR clkload0/A sky130_fd_sc_hd__clkbuf_16
XFILLER_0_125 VGND VGND VPWR VPWR sky130_fd_sc_hd__fill_1
XFILLER_0_169 VGND VGND VPWR VPWR sky130_fd_sc_hd__decap_12
XFILLER_44_20 VGND VGND VPWR VPWR sky130_fd_sc_hd__decap_8
XFILLER_60_41 VGND VGND VPWR VPWR sky130_fd_sc_hd__fill_1
XTAP_TAPCELL_ROW_22_260 VGND VPWR sky130_fd_sc_hd__tapvpwrvgnd_1
XFILLER_62_110 VGND VGND VPWR VPWR sky130_fd_sc_hd__fill_2
X_2020_ _2020_/A _2020_/B VGND VGND VPWR VPWR _2020_/Y sky130_fd_sc_hd__nor2_1
XTAP_TAPCELL_ROW_45_374 VGND VPWR sky130_fd_sc_hd__tapvpwrvgnd_1
X_1804_ _1804_/A _1804_/B VGND VGND VPWR VPWR _2500_/D sky130_fd_sc_hd__xnor2_1
Xhold247 _1973_/Y VGND VGND VPWR VPWR _2557_/D sky130_fd_sc_hd__dlygate4sd3_1
Xhold203 _1961_/Y VGND VGND VPWR VPWR _2553_/D sky130_fd_sc_hd__dlygate4sd3_1
Xhold214 _2530_/Q VGND VGND VPWR VPWR _1891_/A sky130_fd_sc_hd__dlygate4sd3_1
Xhold236 _1880_/Y VGND VGND VPWR VPWR _2526_/D sky130_fd_sc_hd__dlygate4sd3_1
Xhold225 _2539_/Q VGND VGND VPWR VPWR _1918_/A sky130_fd_sc_hd__dlygate4sd3_1
Xhold269 _2566_/Q VGND VGND VPWR VPWR hold269/X sky130_fd_sc_hd__dlygate4sd3_1
X_1666_ _2480_/Q _1690_/A _1690_/B VGND VGND VPWR VPWR _1695_/B sky130_fd_sc_hd__nand3_1
X_1735_ _2458_/Q _2400_/Q VGND VGND VPWR VPWR _2121_/A sky130_fd_sc_hd__nor2_1
Xhold258 _2516_/Q VGND VGND VPWR VPWR _1849_/A sky130_fd_sc_hd__dlygate4sd3_1
Xload_slew172 fanout171/X VGND VGND VPWR VPWR load_slew172/X sky130_fd_sc_hd__buf_4
X_1597_ _2630_/Q _1598_/B VGND VGND VPWR VPWR _1600_/B sky130_fd_sc_hd__and2_0
Xload_slew150 fanout149/X VGND VGND VPWR VPWR load_slew150/X sky130_fd_sc_hd__buf_4
XTAP_TAPCELL_ROW_68_488 VGND VPWR sky130_fd_sc_hd__tapvpwrvgnd_1
X_2218_ _2220_/A _2220_/B VGND VGND VPWR VPWR _2219_/A sky130_fd_sc_hd__nand2_1
XTAP_TAPCELL_ROW_36_330 VGND VPWR sky130_fd_sc_hd__tapvpwrvgnd_1
X_2149_ _2273_/A _2149_/B VGND VGND VPWR VPWR _2152_/B sky130_fd_sc_hd__nand2_1
XFILLER_14_23 VGND VGND VPWR VPWR sky130_fd_sc_hd__decap_4
XTAP_TAPCELL_ROW_59_444 VGND VPWR sky130_fd_sc_hd__tapvpwrvgnd_1
XFILLER_55_41 VGND VGND VPWR VPWR sky130_fd_sc_hd__fill_1
XFILLER_29_140 VGND VGND VPWR VPWR sky130_fd_sc_hd__fill_1
XFILLER_44_165 VGND VGND VPWR VPWR sky130_fd_sc_hd__fill_1
X_1520_ _1486_/D _1519_/Y _1482_/Y VGND VGND VPWR VPWR _1521_/B sky130_fd_sc_hd__a21oi_1
X_1382_ _2283_/A _2242_/B VGND VGND VPWR VPWR _1382_/Y sky130_fd_sc_hd__nand2_1
X_1451_ _1449_/Y _1450_/Y _2485_/Q _1415_/Y VGND VGND VPWR VPWR _1451_/Y sky130_fd_sc_hd__o2bb2ai_1
X_2003_ hold320/X _2408_/Q _2003_/S VGND VGND VPWR VPWR _2583_/D sky130_fd_sc_hd__mux2_1
X_1718_ _2444_/Q _2386_/Q VGND VGND VPWR VPWR _2128_/B sky130_fd_sc_hd__nor2_1
X_1649_ _2470_/Q _2468_/Q VGND VGND VPWR VPWR _1650_/B sky130_fd_sc_hd__xnor2_1
XFILLER_58_268 VGND VGND VPWR VPWR sky130_fd_sc_hd__fill_1
XFILLER_41_146 VGND VGND VPWR VPWR sky130_fd_sc_hd__fill_1
XFILLER_25_55 VGND VGND VPWR VPWR sky130_fd_sc_hd__fill_1
XFILLER_41_43 VGND VGND VPWR VPWR sky130_fd_sc_hd__decap_4
XFILLER_64_227 VGND VGND VPWR VPWR sky130_fd_sc_hd__decap_12
XFILLER_64_216 VGND VGND VPWR VPWR sky130_fd_sc_hd__fill_2
XFILLER_49_279 VGND VGND VPWR VPWR sky130_fd_sc_hd__fill_1
XFILLER_17_187 VGND VGND VPWR VPWR sky130_fd_sc_hd__fill_2
XFILLER_56_3 VGND VGND VPWR VPWR sky130_fd_sc_hd__decap_6
X_2621_ _2633_/CLK _2621_/D fanout187/A VGND VGND VPWR VPWR _2621_/Q sky130_fd_sc_hd__dfrtp_1
X_1503_ _2176_/A locked _1469_/Y _1502_/Y VGND VGND VPWR VPWR _1503_/Y sky130_fd_sc_hd__a31oi_1
X_2552_ clkload9/A _2552_/D load_slew166/X VGND VGND VPWR VPWR _2552_/Q sky130_fd_sc_hd__dfrtp_1
X_2483_ clkload4/A _2483_/D fanout159/A VGND VGND VPWR VPWR _2483_/Q sky130_fd_sc_hd__dfrtp_1
X_1434_ _2474_/Q _1434_/B _1434_/C VGND VGND VPWR VPWR _1435_/C sky130_fd_sc_hd__maj3_1
XFILLER_55_238 VGND VGND VPWR VPWR sky130_fd_sc_hd__fill_1
X_1296_ _2476_/Q _1296_/B VGND VGND VPWR VPWR _1296_/Y sky130_fd_sc_hd__nand2_1
X_1365_ _2484_/Q _1356_/B _1368_/B _2318_/A VGND VGND VPWR VPWR _1365_/X sky130_fd_sc_hd__a22o_1
XFILLER_23_113 VGND VGND VPWR VPWR sky130_fd_sc_hd__fill_1
XFILLER_11_57 VGND VGND VPWR VPWR sky130_fd_sc_hd__decap_6
XFILLER_61_219 VGND VGND VPWR VPWR sky130_fd_sc_hd__decap_4
XFILLER_54_271 VGND VGND VPWR VPWR sky130_fd_sc_hd__decap_8
XFILLER_46_249 VGND VGND VPWR VPWR sky130_fd_sc_hd__decap_3
XPHY_EDGE_ROW_30_Left_101 VGND VGND VPWR VPWR sky130_fd_sc_hd__decap_3
XTAP_TAPCELL_ROW_9_194 VGND VPWR sky130_fd_sc_hd__tapvpwrvgnd_1
X_2604_ clkload8/A _2604_/D wire181/X VGND VGND VPWR VPWR _2604_/Q sky130_fd_sc_hd__dfrtp_1
X_1983_ hold297/X _2388_/Q _2034_/B VGND VGND VPWR VPWR _2563_/D sky130_fd_sc_hd__mux2_1
X_2466_ _2633_/CLK _2466_/D wire181/X VGND VGND VPWR VPWR _2466_/Q sky130_fd_sc_hd__dfrtp_1
X_2535_ _2606_/CLK _2535_/D fanout183/A VGND VGND VPWR VPWR _2535_/Q sky130_fd_sc_hd__dfrtp_1
X_1417_ _1445_/A _1417_/A2 _1379_/Y VGND VGND VPWR VPWR _1418_/B sky130_fd_sc_hd__o21ai_0
X_1279_ _2185_/B _2423_/Q VGND VGND VPWR VPWR _1430_/A sky130_fd_sc_hd__nand2_1
X_2397_ clkload1/A _2397_/D load_slew144/X VGND VGND VPWR VPWR _2397_/Q sky130_fd_sc_hd__dfrtp_1
X_1348_ _2274_/A _1337_/Y _1347_/Y _2483_/Q VGND VGND VPWR VPWR _1348_/Y sky130_fd_sc_hd__o22ai_1
XFILLER_51_274 VGND VGND VPWR VPWR sky130_fd_sc_hd__decap_6
XFILLER_36_282 VGND VGND VPWR VPWR sky130_fd_sc_hd__fill_1
XFILLER_22_23 VGND VGND VPWR VPWR sky130_fd_sc_hd__decap_4
Xfanout140 _2423_/Q VGND VGND VPWR VPWR _2171_/A sky130_fd_sc_hd__clkdlybuf4s50_1
Xfanout173 fanout191/X VGND VGND VPWR VPWR fanout173/X sky130_fd_sc_hd__clkdlybuf4s50_1
Xfanout151 fanout156/X VGND VGND VPWR VPWR fanout151/X sky130_fd_sc_hd__clkdlybuf4s50_1
XFILLER_27_271 VGND VGND VPWR VPWR sky130_fd_sc_hd__decap_8
X_2251_ _2249_/Y _2250_/X _2297_/A VGND VGND VPWR VPWR _2251_/Y sky130_fd_sc_hd__a21oi_1
X_2320_ _2317_/X _2318_/Y _2304_/Y _2306_/Y VGND VGND VPWR VPWR _2320_/Y sky130_fd_sc_hd__o211ai_1
XFILLER_6_197 VGND VGND VPWR VPWR sky130_fd_sc_hd__decap_6
X_2182_ _2136_/B _2180_/Y _2181_/Y _2254_/B2 _1200_/Y VGND VGND VPWR VPWR _2424_/D
+ sky130_fd_sc_hd__a32oi_1
X_1202_ _2316_/B VGND VGND VPWR VPWR _1202_/Y sky130_fd_sc_hd__inv_1
XFILLER_19_3 VGND VGND VPWR VPWR sky130_fd_sc_hd__decap_3
X_1966_ _1966_/A _1966_/B VGND VGND VPWR VPWR _1966_/Y sky130_fd_sc_hd__nand2_1
X_1897_ _1897_/A _1969_/B VGND VGND VPWR VPWR _1897_/Y sky130_fd_sc_hd__nand2_1
X_2518_ _2592_/CLK _2518_/D fanout148/X VGND VGND VPWR VPWR _2518_/Q sky130_fd_sc_hd__dfrtp_1
X_2449_ clkload2/A _2449_/D fanout149/X VGND VGND VPWR VPWR _2449_/Q sky130_fd_sc_hd__dfrtp_1
XFILLER_24_241 VGND VGND VPWR VPWR sky130_fd_sc_hd__fill_2
XFILLER_3_167 VGND VGND VPWR VPWR sky130_fd_sc_hd__fill_1
XFILLER_66_108 VGND VGND VPWR VPWR sky130_fd_sc_hd__decap_8
X_1820_ _2508_/Q _1828_/B VGND VGND VPWR VPWR _1829_/B sky130_fd_sc_hd__nand2_1
XFILLER_30_222 VGND VGND VPWR VPWR sky130_fd_sc_hd__decap_4
XTAP_TAPCELL_ROW_17_236 VGND VPWR sky130_fd_sc_hd__tapvpwrvgnd_1
X_1682_ _1680_/A _1680_/B _2201_/C VGND VGND VPWR VPWR _1683_/B sky130_fd_sc_hd__o21ai_0
X_1751_ _2461_/Q _2403_/Q VGND VGND VPWR VPWR _2119_/A sky130_fd_sc_hd__nor2_1
XFILLER_57_108 VGND VGND VPWR VPWR sky130_fd_sc_hd__fill_1
X_2234_ _2234_/A _2234_/B _2234_/C VGND VGND VPWR VPWR _2234_/X sky130_fd_sc_hd__or3_1
X_2303_ _2305_/B _2351_/B VGND VGND VPWR VPWR _2303_/Y sky130_fd_sc_hd__nor2_1
XFILLER_65_185 VGND VGND VPWR VPWR sky130_fd_sc_hd__fill_1
X_2165_ _2171_/A _2255_/B _2173_/A VGND VGND VPWR VPWR _2165_/Y sky130_fd_sc_hd__o21ai_0
XTAP_TAPCELL_ROW_0_148 VGND VPWR sky130_fd_sc_hd__tapvpwrvgnd_1
X_2096_ _2096_/A _2096_/B _2096_/C VGND VGND VPWR VPWR _2114_/C sky130_fd_sc_hd__nand3_1
X_1949_ _1948_/B _1947_/Y _1948_/Y VGND VGND VPWR VPWR _2549_/D sky130_fd_sc_hd__o21ai_0
XFILLER_21_244 VGND VGND VPWR VPWR sky130_fd_sc_hd__decap_12
XFILLER_0_159 VGND VGND VPWR VPWR sky130_fd_sc_hd__decap_8
XTAP_TAPCELL_ROW_14_217 VGND VPWR sky130_fd_sc_hd__tapvpwrvgnd_1
XFILLER_8_226 VGND VGND VPWR VPWR sky130_fd_sc_hd__fill_1
XTAP_TAPCELL_ROW_22_261 VGND VPWR sky130_fd_sc_hd__tapvpwrvgnd_1
XPHY_EDGE_ROW_13_Right_13 VGND VGND VPWR VPWR sky130_fd_sc_hd__decap_3
X_1803_ _2499_/Q _2500_/Q _1805_/D VGND VGND VPWR VPWR _1806_/B sky130_fd_sc_hd__nand3_1
XTAP_TAPCELL_ROW_45_375 VGND VPWR sky130_fd_sc_hd__tapvpwrvgnd_1
XPHY_EDGE_ROW_22_Right_22 VGND VGND VPWR VPWR sky130_fd_sc_hd__decap_3
XPHY_EDGE_ROW_68_Left_139 VGND VGND VPWR VPWR sky130_fd_sc_hd__decap_3
Xhold215 _1892_/Y VGND VGND VPWR VPWR _2530_/D sky130_fd_sc_hd__dlygate4sd3_1
Xhold248 _2513_/Q VGND VGND VPWR VPWR _1840_/A sky130_fd_sc_hd__dlygate4sd3_1
Xhold259 _2577_/Q VGND VGND VPWR VPWR hold259/X sky130_fd_sc_hd__dlygate4sd3_1
Xhold204 _2551_/Q VGND VGND VPWR VPWR _1954_/A sky130_fd_sc_hd__dlygate4sd3_1
X_1596_ _1603_/A _1598_/B _1596_/C VGND VGND VPWR VPWR _2629_/D sky130_fd_sc_hd__nor3_1
Xhold226 _1919_/Y VGND VGND VPWR VPWR _2539_/D sky130_fd_sc_hd__dlygate4sd3_1
XFILLER_7_281 VGND VGND VPWR VPWR sky130_fd_sc_hd__decap_8
Xhold237 _2547_/Q VGND VGND VPWR VPWR _1942_/A sky130_fd_sc_hd__dlygate4sd3_1
X_1734_ _2456_/Q _2398_/Q _2455_/Q _2397_/Q VGND VGND VPWR VPWR _1734_/Y sky130_fd_sc_hd__a22oi_1
X_1665_ _1690_/A _1690_/B VGND VGND VPWR VPWR _1692_/B sky130_fd_sc_hd__nand2_1
XTAP_TAPCELL_ROW_68_489 VGND VPWR sky130_fd_sc_hd__tapvpwrvgnd_1
X_2217_ _2198_/A _2137_/A _2199_/Y VGND VGND VPWR VPWR _2220_/B sky130_fd_sc_hd__o21ai_0
Xload_slew184 fanout183/X VGND VGND VPWR VPWR _2429_/SET_B sky130_fd_sc_hd__buf_4
XFILLER_38_152 VGND VGND VPWR VPWR sky130_fd_sc_hd__decap_4
Xload_slew162 fanout161/X VGND VGND VPWR VPWR load_slew162/X sky130_fd_sc_hd__buf_4
XPHY_EDGE_ROW_31_Right_31 VGND VGND VPWR VPWR sky130_fd_sc_hd__decap_3
XFILLER_53_166 VGND VGND VPWR VPWR sky130_fd_sc_hd__fill_2
XTAP_TAPCELL_ROW_36_331 VGND VPWR sky130_fd_sc_hd__tapvpwrvgnd_1
X_2079_ _2101_/A _2080_/B _2083_/B1 _2080_/D _2409_/Q VGND VGND VPWR VPWR _2079_/Y
+ sky130_fd_sc_hd__o2111ai_1
X_2148_ _2287_/B _1692_/A _2147_/Y VGND VGND VPWR VPWR _2148_/Y sky130_fd_sc_hd__o21ai_0
XPHY_EDGE_ROW_40_Right_40 VGND VGND VPWR VPWR sky130_fd_sc_hd__decap_3
XFILLER_30_23 VGND VGND VPWR VPWR sky130_fd_sc_hd__decap_4
XFILLER_39_65 VGND VGND VPWR VPWR sky130_fd_sc_hd__fill_1
XFILLER_39_43 VGND VGND VPWR VPWR sky130_fd_sc_hd__fill_1
XTAP_TAPCELL_ROW_59_445 VGND VPWR sky130_fd_sc_hd__tapvpwrvgnd_1
XFILLER_55_31 VGND VGND VPWR VPWR sky130_fd_sc_hd__fill_1
XFILLER_44_144 VGND VGND VPWR VPWR sky130_fd_sc_hd__fill_1
XFILLER_44_111 VGND VGND VPWR VPWR sky130_fd_sc_hd__decap_8
X_1450_ _2485_/Q _1415_/Y _1416_/Y _2484_/Q VGND VGND VPWR VPWR _1450_/Y sky130_fd_sc_hd__a22oi_1
X_1381_ _2272_/A _2287_/B _2283_/A _1486_/A VGND VGND VPWR VPWR _1381_/X sky130_fd_sc_hd__o211a_1
X_2002_ hold298/X _2407_/Q _2003_/S VGND VGND VPWR VPWR _2582_/D sky130_fd_sc_hd__mux2_1
XFILLER_35_177 VGND VGND VPWR VPWR sky130_fd_sc_hd__fill_2
XTAP_TAPCELL_ROW_33_312 VGND VPWR sky130_fd_sc_hd__tapvpwrvgnd_1
XFILLER_58_214 VGND VGND VPWR VPWR sky130_fd_sc_hd__fill_1
XFILLER_58_203 VGND VGND VPWR VPWR sky130_fd_sc_hd__fill_2
X_1579_ _2622_/Q _1578_/C _2623_/Q VGND VGND VPWR VPWR _1580_/C sky130_fd_sc_hd__a21oi_1
X_1717_ _2445_/Q _2387_/Q VGND VGND VPWR VPWR _2128_/A sky130_fd_sc_hd__nor2_1
X_1648_ _2470_/Q _2468_/Q VGND VGND VPWR VPWR _1648_/Y sky130_fd_sc_hd__nor2b_1
XTAP_TAPCELL_ROW_64_470 VGND VPWR sky130_fd_sc_hd__tapvpwrvgnd_1
XFILLER_41_169 VGND VGND VPWR VPWR sky130_fd_sc_hd__decap_6
XFILLER_41_55 VGND VGND VPWR VPWR sky130_fd_sc_hd__fill_1
XFILLER_64_206 VGND VGND VPWR VPWR sky130_fd_sc_hd__fill_2
XFILLER_49_225 VGND VGND VPWR VPWR sky130_fd_sc_hd__fill_2
XFILLER_1_265 VGND VGND VPWR VPWR sky130_fd_sc_hd__decap_12
XFILLER_64_239 VGND VGND VPWR VPWR sky130_fd_sc_hd__decap_3
XFILLER_17_122 VGND VGND VPWR VPWR sky130_fd_sc_hd__decap_3
X_2620_ _2633_/CLK _2620_/D fanout187/A VGND VGND VPWR VPWR _2620_/Q sky130_fd_sc_hd__dfrtp_1
X_1433_ _2473_/Q _1433_/B _1433_/C VGND VGND VPWR VPWR _1434_/C sky130_fd_sc_hd__maj3_1
X_1502_ _1523_/A _1502_/B VGND VGND VPWR VPWR _1502_/Y sky130_fd_sc_hd__nor2_1
X_2551_ clkload9/A _2551_/D load_slew168/X VGND VGND VPWR VPWR _2551_/Q sky130_fd_sc_hd__dfrtp_1
X_2482_ clkload4/A _2482_/D fanout159/A VGND VGND VPWR VPWR _2482_/Q sky130_fd_sc_hd__dfrtp_1
X_1295_ _1295_/A _1295_/B VGND VGND VPWR VPWR _1296_/B sky130_fd_sc_hd__xor2_1
X_1364_ _1371_/A _1364_/B VGND VGND VPWR VPWR _1368_/B sky130_fd_sc_hd__xor2_1
XFILLER_23_169 VGND VGND VPWR VPWR sky130_fd_sc_hd__fill_2
XFILLER_31_191 VGND VGND VPWR VPWR sky130_fd_sc_hd__decap_4
XFILLER_46_217 VGND VGND VPWR VPWR sky130_fd_sc_hd__decap_8
XFILLER_14_136 VGND VGND VPWR VPWR sky130_fd_sc_hd__fill_1
XFILLER_22_180 VGND VGND VPWR VPWR sky130_fd_sc_hd__decap_12
XTAP_TAPCELL_ROW_9_195 VGND VPWR sky130_fd_sc_hd__tapvpwrvgnd_1
XFILLER_60_253 VGND VGND VPWR VPWR sky130_fd_sc_hd__decap_6
X_1982_ hold300/X _2387_/Q _2010_/B VGND VGND VPWR VPWR _1982_/X sky130_fd_sc_hd__mux2_1
XFILLER_20_139 VGND VGND VPWR VPWR sky130_fd_sc_hd__fill_1
X_2603_ clkload9/A _2603_/D fanout173/X VGND VGND VPWR VPWR _2603_/Q sky130_fd_sc_hd__dfrtp_1
X_2534_ _2606_/CLK _2534_/D _2429_/SET_B VGND VGND VPWR VPWR _2534_/Q sky130_fd_sc_hd__dfrtp_1
X_2465_ _2607_/CLK _2465_/D wire181/X VGND VGND VPWR VPWR _2465_/Q sky130_fd_sc_hd__dfrtp_1
XFILLER_3_70 VGND VGND VPWR VPWR sky130_fd_sc_hd__fill_2
X_2396_ clkload1/A _2396_/D load_slew150/X VGND VGND VPWR VPWR _2396_/Q sky130_fd_sc_hd__dfrtp_1
X_1416_ _1416_/A _1416_/B VGND VGND VPWR VPWR _1416_/Y sky130_fd_sc_hd__xnor2_1
X_1347_ _1357_/A _1347_/B VGND VGND VPWR VPWR _1347_/Y sky130_fd_sc_hd__nand2_1
X_1278_ _1431_/B _2423_/Q _1277_/Y VGND VGND VPWR VPWR _1282_/B sky130_fd_sc_hd__o21ai_0
Xwire43 wire43/A VGND VGND VPWR VPWR wire43/X sky130_fd_sc_hd__clkdlybuf4s25_1
Xwire32 wire32/A VGND VGND VPWR VPWR wire32/X sky130_fd_sc_hd__clkdlybuf4s25_1
XFILLER_28_239 VGND VGND VPWR VPWR sky130_fd_sc_hd__decap_3
Xfanout174 fanout182/X VGND VGND VPWR VPWR fanout174/X sky130_fd_sc_hd__clkdlybuf4s50_1
Xfanout130 _2230_/B VGND VGND VPWR VPWR _2201_/A sky130_fd_sc_hd__clkdlybuf4s50_1
Xfanout185 fanout191/X VGND VGND VPWR VPWR fanout185/X sky130_fd_sc_hd__clkdlybuf4s50_1
Xfanout141 fanout145/X VGND VGND VPWR VPWR fanout141/X sky130_fd_sc_hd__clkdlybuf4s50_1
Xfanout163 fanout192/X VGND VGND VPWR VPWR fanout163/X sky130_fd_sc_hd__clkdlybuf4s50_1
XPHY_EDGE_ROW_69_Right_69 VGND VGND VPWR VPWR sky130_fd_sc_hd__decap_3
XFILLER_42_220 VGND VGND VPWR VPWR sky130_fd_sc_hd__decap_12
XFILLER_8_15 VGND VGND VPWR VPWR sky130_fd_sc_hd__fill_2
XFILLER_6_132 VGND VGND VPWR VPWR sky130_fd_sc_hd__decap_8
X_1201_ _2171_/A VGND VGND VPWR VPWR _1201_/Y sky130_fd_sc_hd__inv_1
X_2250_ _2236_/A _2234_/X _2248_/X _2235_/A VGND VGND VPWR VPWR _2250_/X sky130_fd_sc_hd__a211o_1
X_2181_ _2173_/A _2175_/X _2254_/B2 VGND VGND VPWR VPWR _2181_/Y sky130_fd_sc_hd__a21oi_1
XPHY_EDGE_ROW_25_Left_96 VGND VGND VPWR VPWR sky130_fd_sc_hd__decap_3
X_1965_ _2554_/Q _2580_/Q _1965_/S VGND VGND VPWR VPWR _1965_/Y sky130_fd_sc_hd__mux2i_1
X_1896_ _2531_/Q _2605_/Q _1902_/S VGND VGND VPWR VPWR _1896_/Y sky130_fd_sc_hd__mux2i_1
X_2517_ clkload1/A _2517_/D load_slew150/X VGND VGND VPWR VPWR _2517_/Q sky130_fd_sc_hd__dfrtp_1
X_2379_ _2379_/A _2445_/Q VGND VGND VPWR VPWR _2379_/Y sky130_fd_sc_hd__nand2_1
X_2448_ clkload2/A _2448_/D fanout155/X VGND VGND VPWR VPWR _2448_/Q sky130_fd_sc_hd__dfrtp_1
XFILLER_17_57 VGND VGND VPWR VPWR sky130_fd_sc_hd__decap_4
XFILLER_24_220 VGND VGND VPWR VPWR sky130_fd_sc_hd__fill_1
XFILLER_24_253 VGND VGND VPWR VPWR sky130_fd_sc_hd__fill_1
X_1750_ _2038_/B _1749_/Y _1708_/Y VGND VGND VPWR VPWR _2487_/D sky130_fd_sc_hd__a21oi_1
XFILLER_30_256 VGND VGND VPWR VPWR sky130_fd_sc_hd__fill_1
X_1681_ _1671_/Y _1680_/Y _2136_/A VGND VGND VPWR VPWR _2475_/D sky130_fd_sc_hd__a21oi_1
X_2233_ _2234_/A _2234_/B _2234_/C VGND VGND VPWR VPWR _2235_/A sky130_fd_sc_hd__o21a_1
XFILLER_31_3 VGND VGND VPWR VPWR sky130_fd_sc_hd__decap_4
X_2302_ _2259_/A _2359_/S _2301_/Y VGND VGND VPWR VPWR _2302_/Y sky130_fd_sc_hd__a21oi_1
X_2164_ _2153_/Y _2159_/Y wire37/X _2163_/Y VGND VGND VPWR VPWR _2164_/Y sky130_fd_sc_hd__a31oi_1
XTAP_TAPCELL_ROW_0_149 VGND VPWR sky130_fd_sc_hd__tapvpwrvgnd_1
X_2095_ _2096_/A _2096_/B _2096_/C VGND VGND VPWR VPWR _2108_/B sky130_fd_sc_hd__and3_1
XFILLER_21_212 VGND VGND VPWR VPWR sky130_fd_sc_hd__decap_4
X_1879_ _1879_/A _1951_/B VGND VGND VPWR VPWR _1879_/Y sky130_fd_sc_hd__nand2_1
X_1948_ _1948_/A _1948_/B VGND VGND VPWR VPWR _1948_/Y sky130_fd_sc_hd__nand2_1
XFILLER_21_256 VGND VGND VPWR VPWR sky130_fd_sc_hd__decap_4
XFILLER_0_149 VGND VGND VPWR VPWR sky130_fd_sc_hd__decap_6
XFILLER_56_197 VGND VGND VPWR VPWR sky130_fd_sc_hd__decap_12
XFILLER_28_56 VGND VGND VPWR VPWR sky130_fd_sc_hd__fill_1
XFILLER_44_11 VGND VGND VPWR VPWR sky130_fd_sc_hd__fill_1
XFILLER_8_216 VGND VGND VPWR VPWR sky130_fd_sc_hd__fill_2
XFILLER_12_201 VGND VGND VPWR VPWR sky130_fd_sc_hd__fill_1
XTAP_TAPCELL_ROW_14_218 VGND VPWR sky130_fd_sc_hd__tapvpwrvgnd_1
XFILLER_60_98 VGND VGND VPWR VPWR sky130_fd_sc_hd__fill_1
XFILLER_69_96 VGND VGND VPWR VPWR sky130_fd_sc_hd__decap_3
XTAP_TAPCELL_ROW_45_376 VGND VPWR sky130_fd_sc_hd__tapvpwrvgnd_1
X_1802_ _1812_/A _1805_/D VGND VGND VPWR VPWR _2499_/D sky130_fd_sc_hd__xnor2_1
X_1733_ _2452_/Q _2394_/Q VGND VGND VPWR VPWR _2125_/B sky130_fd_sc_hd__nor2_1
X_1664_ _1688_/A _1688_/B VGND VGND VPWR VPWR _1690_/B sky130_fd_sc_hd__nor2_1
X_1595_ _2628_/Q _1594_/C _2629_/Q VGND VGND VPWR VPWR _1596_/C sky130_fd_sc_hd__a21oi_1
Xhold249 _2537_/Q VGND VGND VPWR VPWR _1912_/A sky130_fd_sc_hd__dlygate4sd3_1
Xhold216 _2522_/Q VGND VGND VPWR VPWR _1867_/A sky130_fd_sc_hd__dlygate4sd3_1
Xhold238 _2521_/Q VGND VGND VPWR VPWR _1864_/A sky130_fd_sc_hd__dlygate4sd3_1
Xhold227 _2541_/Q VGND VGND VPWR VPWR _1924_/A sky130_fd_sc_hd__dlygate4sd3_1
Xhold205 _2540_/Q VGND VGND VPWR VPWR _1921_/A sky130_fd_sc_hd__dlygate4sd3_1
X_2216_ _2216_/A _2234_/B VGND VGND VPWR VPWR _2220_/A sky130_fd_sc_hd__nor2_1
X_2147_ _2272_/B _1690_/A _2145_/Y _2146_/Y VGND VGND VPWR VPWR _2147_/Y sky130_fd_sc_hd__o22ai_1
XFILLER_38_197 VGND VGND VPWR VPWR sky130_fd_sc_hd__decap_8
Xload_slew152 fanout151/X VGND VGND VPWR VPWR load_slew152/X sky130_fd_sc_hd__buf_4
X_2078_ _2101_/A _2080_/B _2083_/B1 _2080_/D VGND VGND VPWR VPWR _2078_/Y sky130_fd_sc_hd__o211ai_1
XPHY_EDGE_ROW_12_Left_83 VGND VGND VPWR VPWR sky130_fd_sc_hd__decap_3
XTAP_TAPCELL_ROW_59_446 VGND VPWR sky130_fd_sc_hd__tapvpwrvgnd_1
XFILLER_39_33 VGND VGND VPWR VPWR sky130_fd_sc_hd__fill_2
XFILLER_44_178 VGND VGND VPWR VPWR sky130_fd_sc_hd__decap_12
XFILLER_29_175 VGND VGND VPWR VPWR sky130_fd_sc_hd__fill_1
XTAP_TAPCELL_ROW_42_357 VGND VPWR sky130_fd_sc_hd__tapvpwrvgnd_1
XFILLER_4_263 VGND VGND VPWR VPWR sky130_fd_sc_hd__decap_12
XFILLER_4_241 VGND VGND VPWR VPWR sky130_fd_sc_hd__decap_8
X_1380_ _2435_/Q _2257_/A VGND VGND VPWR VPWR _1445_/A sky130_fd_sc_hd__xnor2_1
XFILLER_67_237 VGND VGND VPWR VPWR sky130_fd_sc_hd__decap_4
X_2001_ hold277/X _2406_/Q _2003_/S VGND VGND VPWR VPWR _2581_/D sky130_fd_sc_hd__mux2_1
XTAP_TAPCELL_ROW_33_313 VGND VPWR sky130_fd_sc_hd__tapvpwrvgnd_1
X_1716_ _2444_/Q _2386_/Q _2443_/Q _2385_/Q VGND VGND VPWR VPWR _1716_/Y sky130_fd_sc_hd__a22oi_1
X_1578_ _2623_/Q _2622_/Q _1578_/C VGND VGND VPWR VPWR _1584_/C sky130_fd_sc_hd__and3_1
X_1647_ hold381/X _1464_/C _1646_/Y _1464_/B VGND VGND VPWR VPWR _2467_/D sky130_fd_sc_hd__a22o_1
XTAP_TAPCELL_ROW_56_427 VGND VPWR sky130_fd_sc_hd__tapvpwrvgnd_1
XFILLER_26_167 VGND VGND VPWR VPWR sky130_fd_sc_hd__decap_8
XTAP_TAPCELL_ROW_64_471 VGND VPWR sky130_fd_sc_hd__tapvpwrvgnd_1
XFILLER_41_23 VGND VGND VPWR VPWR sky130_fd_sc_hd__fill_1
XFILLER_25_57 VGND VGND VPWR VPWR sky130_fd_sc_hd__fill_2
XFILLER_1_233 VGND VGND VPWR VPWR sky130_fd_sc_hd__fill_2
XFILLER_9_3 VGND VGND VPWR VPWR sky130_fd_sc_hd__decap_8
XFILLER_57_281 VGND VGND VPWR VPWR sky130_fd_sc_hd__decap_8
XFILLER_49_248 VGND VGND VPWR VPWR sky130_fd_sc_hd__fill_2
XFILLER_49_237 VGND VGND VPWR VPWR sky130_fd_sc_hd__decap_3
XFILLER_1_277 VGND VGND VPWR VPWR sky130_fd_sc_hd__decap_3
XFILLER_17_145 VGND VGND VPWR VPWR sky130_fd_sc_hd__fill_1
X_2550_ clkload9/A _2550_/D load_slew168/X VGND VGND VPWR VPWR _2550_/Q sky130_fd_sc_hd__dfrtp_1
X_1432_ _2472_/Q _1432_/B _1432_/C VGND VGND VPWR VPWR _1433_/C sky130_fd_sc_hd__maj3_1
X_1501_ _1523_/A _1500_/Y _1573_/C VGND VGND VPWR VPWR _1504_/C sky130_fd_sc_hd__o21bai_1
X_1363_ _1202_/Y _2331_/B _1362_/Y VGND VGND VPWR VPWR _1363_/Y sky130_fd_sc_hd__a21oi_1
X_2481_ clkload4/A _2481_/D fanout159/X VGND VGND VPWR VPWR _2481_/Q sky130_fd_sc_hd__dfrtp_1
X_1294_ _1289_/A _1289_/B _1289_/C _1287_/B VGND VGND VPWR VPWR _1295_/B sky130_fd_sc_hd__a31oi_1
XTAP_TAPCELL_ROW_61_452 VGND VPWR sky130_fd_sc_hd__tapvpwrvgnd_1
XFILLER_23_137 VGND VGND VPWR VPWR sky130_fd_sc_hd__decap_3
XFILLER_23_148 VGND VGND VPWR VPWR sky130_fd_sc_hd__decap_12
XFILLER_11_37 VGND VGND VPWR VPWR sky130_fd_sc_hd__decap_8
XFILLER_54_262 VGND VGND VPWR VPWR sky130_fd_sc_hd__decap_4
XFILLER_54_251 VGND VGND VPWR VPWR sky130_fd_sc_hd__fill_1
XFILLER_36_89 VGND VGND VPWR VPWR sky130_fd_sc_hd__fill_2
XFILLER_52_88 VGND VGND VPWR VPWR sky130_fd_sc_hd__decap_4
XFILLER_22_192 VGND VGND VPWR VPWR sky130_fd_sc_hd__decap_4
XTAP_TAPCELL_ROW_9_196 VGND VPWR sky130_fd_sc_hd__tapvpwrvgnd_1
X_1981_ hold289/X _2386_/Q _2010_/B VGND VGND VPWR VPWR _1981_/X sky130_fd_sc_hd__mux2_1
XFILLER_61_3 VGND VGND VPWR VPWR sky130_fd_sc_hd__fill_1
X_2533_ _2606_/CLK _2533_/D wire181/X VGND VGND VPWR VPWR _2533_/Q sky130_fd_sc_hd__dfrtp_1
X_2602_ clkload9/A _2602_/D load_slew166/X VGND VGND VPWR VPWR _2602_/Q sky130_fd_sc_hd__dfrtp_1
X_2464_ _2606_/CLK _2464_/D wire181/X VGND VGND VPWR VPWR _2464_/Q sky130_fd_sc_hd__dfrtp_1
X_2395_ clkload1/A _2395_/D load_slew144/X VGND VGND VPWR VPWR _2395_/Q sky130_fd_sc_hd__dfrtp_1
X_1415_ _1415_/A _1415_/B VGND VGND VPWR VPWR _1415_/Y sky130_fd_sc_hd__xnor2_1
X_1346_ _1343_/X _1485_/B _1340_/Y _1341_/Y _1342_/Y VGND VGND VPWR VPWR _1347_/B
+ sky130_fd_sc_hd__o2111ai_1
X_1277_ _2187_/B _2171_/A _2471_/Q VGND VGND VPWR VPWR _1277_/Y sky130_fd_sc_hd__a21oi_1
Xfanout131 _2428_/Q VGND VGND VPWR VPWR _2230_/B sky130_fd_sc_hd__clkdlybuf4s50_1
Xfanout120 _2305_/B VGND VGND VPWR VPWR _2257_/A sky130_fd_sc_hd__clkdlybuf4s50_1
XFILLER_47_77 VGND VGND VPWR VPWR sky130_fd_sc_hd__fill_1
Xfanout153 fanout156/X VGND VGND VPWR VPWR fanout153/X sky130_fd_sc_hd__clkdlybuf4s50_1
XTAP_TAPCELL_ROW_6_177 VGND VPWR sky130_fd_sc_hd__tapvpwrvgnd_1
XFILLER_42_232 VGND VGND VPWR VPWR sky130_fd_sc_hd__decap_4
XFILLER_10_195 VGND VGND VPWR VPWR sky130_fd_sc_hd__fill_1
XFILLER_12_80 VGND VGND VPWR VPWR sky130_fd_sc_hd__fill_1
XFILLER_12_91 VGND VGND VPWR VPWR sky130_fd_sc_hd__fill_1
X_1200_ _2187_/B VGND VGND VPWR VPWR _1200_/Y sky130_fd_sc_hd__inv_1
X_2180_ _2187_/B _2283_/B _2179_/Y VGND VGND VPWR VPWR _2180_/Y sky130_fd_sc_hd__o21ai_0
XPHY_EDGE_ROW_0_Left_71 VGND VGND VPWR VPWR sky130_fd_sc_hd__decap_3
XFILLER_33_254 VGND VGND VPWR VPWR sky130_fd_sc_hd__decap_4
XFILLER_18_251 VGND VGND VPWR VPWR sky130_fd_sc_hd__fill_1
XTAP_TAPCELL_ROW_28_290 VGND VPWR sky130_fd_sc_hd__tapvpwrvgnd_1
X_1964_ _1966_/B _1962_/Y _1963_/Y VGND VGND VPWR VPWR _1964_/Y sky130_fd_sc_hd__o21ai_0
X_1895_ _1969_/B _1893_/Y _1894_/Y VGND VGND VPWR VPWR _2531_/D sky130_fd_sc_hd__o21ai_0
Xclkbuf_leaf_13_clk clkbuf_leaf_9_clk/A VGND VGND VPWR VPWR clkload6/A sky130_fd_sc_hd__clkbuf_16
X_2447_ clkload2/A _2447_/D fanout155/X VGND VGND VPWR VPWR _2447_/Q sky130_fd_sc_hd__dfrtp_1
X_2516_ clkload2/A _2516_/D load_slew150/X VGND VGND VPWR VPWR _2516_/Q sky130_fd_sc_hd__dfrtp_1
X_2378_ _1241_/Y _2377_/Y _2380_/S VGND VGND VPWR VPWR _2443_/D sky130_fd_sc_hd__mux2i_1
X_1329_ _1519_/A _1329_/B VGND VGND VPWR VPWR _1341_/A sky130_fd_sc_hd__nor2_1
XFILLER_33_24 VGND VGND VPWR VPWR sky130_fd_sc_hd__fill_2
XFILLER_17_69 VGND VGND VPWR VPWR sky130_fd_sc_hd__decap_8
XFILLER_59_140 VGND VGND VPWR VPWR sky130_fd_sc_hd__decap_3
XFILLER_58_54 VGND VGND VPWR VPWR sky130_fd_sc_hd__decap_12
XFILLER_3_158 VGND VGND VPWR VPWR sky130_fd_sc_hd__fill_1
X_1680_ _1680_/A _1680_/B VGND VGND VPWR VPWR _1680_/Y sky130_fd_sc_hd__xnor2_1
X_2301_ _2305_/B _2359_/S _1557_/A VGND VGND VPWR VPWR _2301_/Y sky130_fd_sc_hd__o21ai_0
Xclkbuf_leaf_2_clk clkload0/A VGND VGND VPWR VPWR clkload8/A sky130_fd_sc_hd__clkbuf_16
X_2232_ _2232_/A _2232_/B VGND VGND VPWR VPWR _2234_/C sky130_fd_sc_hd__xnor2_1
X_2163_ _2156_/Y _2162_/Y _2168_/B VGND VGND VPWR VPWR _2163_/Y sky130_fd_sc_hd__o21ai_0
XFILLER_24_3 VGND VGND VPWR VPWR sky130_fd_sc_hd__decap_8
XFILLER_0_83 VGND VGND VPWR VPWR sky130_fd_sc_hd__fill_1
X_2094_ _2082_/A _2167_/A _2092_/Y _1557_/A VGND VGND VPWR VPWR _2096_/C sky130_fd_sc_hd__a22oi_1
X_1878_ _2525_/Q _2599_/Q _1884_/S VGND VGND VPWR VPWR _1878_/Y sky130_fd_sc_hd__mux2i_1
XFILLER_9_70 VGND VGND VPWR VPWR sky130_fd_sc_hd__fill_2
XFILLER_21_279 VGND VGND VPWR VPWR sky130_fd_sc_hd__fill_1
X_1947_ _2548_/Q _2574_/Q _1947_/S VGND VGND VPWR VPWR _1947_/Y sky130_fd_sc_hd__mux2i_1
XFILLER_0_139 VGND VGND VPWR VPWR sky130_fd_sc_hd__fill_1
XFILLER_56_176 VGND VGND VPWR VPWR sky130_fd_sc_hd__decap_6
XFILLER_12_257 VGND VGND VPWR VPWR sky130_fd_sc_hd__decap_8
XTAP_TAPCELL_ROW_14_219 VGND VPWR sky130_fd_sc_hd__tapvpwrvgnd_1
XFILLER_47_165 VGND VGND VPWR VPWR sky130_fd_sc_hd__decap_3
X_1801_ _2499_/Q _1805_/D VGND VGND VPWR VPWR _1804_/B sky130_fd_sc_hd__nand2_1
Xwire181 wire181/A VGND VGND VPWR VPWR wire181/X sky130_fd_sc_hd__clkbuf_4
X_1663_ _2477_/Q _2476_/Q _1663_/C VGND VGND VPWR VPWR _1688_/B sky130_fd_sc_hd__nand3_1
Xhold217 _2512_/Q VGND VGND VPWR VPWR _1837_/A sky130_fd_sc_hd__dlygate4sd3_1
X_1732_ _2454_/Q _2396_/Q VGND VGND VPWR VPWR _2126_/D sky130_fd_sc_hd__nor2_1
Xhold206 _1922_/Y VGND VGND VPWR VPWR _2540_/D sky130_fd_sc_hd__dlygate4sd3_1
Xhold228 _2554_/Q VGND VGND VPWR VPWR _1963_/A sky130_fd_sc_hd__dlygate4sd3_1
Xhold239 _2552_/Q VGND VGND VPWR VPWR _1957_/A sky130_fd_sc_hd__dlygate4sd3_1
X_1594_ _2629_/Q _2628_/Q _1594_/C VGND VGND VPWR VPWR _1598_/B sky130_fd_sc_hd__and3_1
XPHY_EDGE_ROW_7_Right_7 VGND VGND VPWR VPWR sky130_fd_sc_hd__decap_3
Xload_slew142 fanout141/X VGND VGND VPWR VPWR load_slew142/X sky130_fd_sc_hd__clkbuf_4
Xload_slew164 fanout163/X VGND VGND VPWR VPWR fanout159/A sky130_fd_sc_hd__buf_4
Xload_slew175 fanout174/X VGND VGND VPWR VPWR load_slew175/X sky130_fd_sc_hd__clkbuf_4
XFILLER_53_124 VGND VGND VPWR VPWR sky130_fd_sc_hd__fill_2
XFILLER_53_113 VGND VGND VPWR VPWR sky130_fd_sc_hd__decap_3
Xload_slew186 fanout185/X VGND VGND VPWR VPWR fanout183/A sky130_fd_sc_hd__buf_2
X_2215_ _2478_/Q _2215_/B VGND VGND VPWR VPWR _2234_/B sky130_fd_sc_hd__and2_0
X_2146_ _2283_/A _2232_/A _1688_/A _2257_/B VGND VGND VPWR VPWR _2146_/Y sky130_fd_sc_hd__o22ai_1
X_2077_ _2082_/A _2077_/B VGND VGND VPWR VPWR _2080_/D sky130_fd_sc_hd__nand2_1
XTAP_TAPCELL_ROW_42_358 VGND VPWR sky130_fd_sc_hd__tapvpwrvgnd_1
XTAP_TAPCELL_ROW_10_200 VGND VPWR sky130_fd_sc_hd__tapvpwrvgnd_1
XFILLER_4_275 VGND VGND VPWR VPWR sky130_fd_sc_hd__decap_12
X_2000_ hold283/X _2405_/Q _2000_/S VGND VGND VPWR VPWR _2000_/X sky130_fd_sc_hd__mux2_1
XFILLER_35_113 VGND VGND VPWR VPWR sky130_fd_sc_hd__decap_6
XTAP_TAPCELL_ROW_33_314 VGND VPWR sky130_fd_sc_hd__tapvpwrvgnd_1
X_1715_ _2447_/Q _2389_/Q VGND VGND VPWR VPWR _1715_/Y sky130_fd_sc_hd__nand2_1
XFILLER_6_93 VGND VGND VPWR VPWR sky130_fd_sc_hd__decap_3
X_1646_ _2077_/B _1657_/C _1657_/D VGND VGND VPWR VPWR _1646_/Y sky130_fd_sc_hd__o21ai_0
X_1577_ _1977_/B _1577_/B VGND VGND VPWR VPWR _2622_/D sky130_fd_sc_hd__nor2_1
XTAP_TAPCELL_ROW_56_428 VGND VPWR sky130_fd_sc_hd__tapvpwrvgnd_1
X_2129_ _2129_/A _2129_/B _2129_/C VGND VGND VPWR VPWR _2130_/D sky130_fd_sc_hd__nor3_1
XFILLER_41_57 VGND VGND VPWR VPWR sky130_fd_sc_hd__decap_6
XFILLER_1_201 VGND VGND VPWR VPWR sky130_fd_sc_hd__fill_2
XFILLER_1_256 VGND VGND VPWR VPWR sky130_fd_sc_hd__fill_1
XFILLER_66_54 VGND VGND VPWR VPWR sky130_fd_sc_hd__fill_1
XFILLER_2_29 VGND VGND VPWR VPWR sky130_fd_sc_hd__fill_2
XFILLER_17_113 VGND VGND VPWR VPWR sky130_fd_sc_hd__fill_1
XFILLER_17_135 VGND VGND VPWR VPWR sky130_fd_sc_hd__decap_6
XTAP_TAPCELL_ROW_70_497 VGND VPWR sky130_fd_sc_hd__tapvpwrvgnd_1
X_1500_ _1500_/A _1500_/B VGND VGND VPWR VPWR _1500_/Y sky130_fd_sc_hd__nor2_1
X_2480_ clkload3/A _2480_/D fanout159/A VGND VGND VPWR VPWR _2480_/Q sky130_fd_sc_hd__dfrtp_1
X_1431_ _2471_/Q _1431_/B VGND VGND VPWR VPWR _1432_/C sky130_fd_sc_hd__nand2b_1
X_1293_ _2242_/B _2201_/A VGND VGND VPWR VPWR _1295_/A sky130_fd_sc_hd__xor2_1
X_1362_ _1371_/A _1364_/B VGND VGND VPWR VPWR _1362_/Y sky130_fd_sc_hd__nor2b_1
XFILLER_23_127 VGND VGND VPWR VPWR sky130_fd_sc_hd__fill_1
XTAP_TAPCELL_ROW_61_453 VGND VPWR sky130_fd_sc_hd__tapvpwrvgnd_1
X_1629_ _2383_/A _2459_/Q VGND VGND VPWR VPWR _1629_/Y sky130_fd_sc_hd__nand2_1
XFILLER_36_46 VGND VGND VPWR VPWR sky130_fd_sc_hd__decap_3
XFILLER_52_45 VGND VGND VPWR VPWR sky130_fd_sc_hd__fill_2
XFILLER_52_78 VGND VGND VPWR VPWR sky130_fd_sc_hd__fill_1
XFILLER_45_252 VGND VGND VPWR VPWR sky130_fd_sc_hd__decap_4
X_1980_ _1980_/A _2130_/A VGND VGND VPWR VPWR _1980_/Y sky130_fd_sc_hd__nor2_1
XFILLER_9_153 VGND VGND VPWR VPWR sky130_fd_sc_hd__fill_1
XFILLER_9_164 VGND VGND VPWR VPWR sky130_fd_sc_hd__decap_4
X_2532_ _2606_/CLK _2532_/D load_slew170/X VGND VGND VPWR VPWR _2532_/Q sky130_fd_sc_hd__dfrtp_1
X_2463_ _2606_/CLK _2463_/D load_slew177/X VGND VGND VPWR VPWR _2463_/Q sky130_fd_sc_hd__dfrtp_1
X_2601_ clkload9/A _2601_/D load_slew166/X VGND VGND VPWR VPWR _2601_/Q sky130_fd_sc_hd__dfrtp_1
X_1276_ _2187_/B _2171_/A VGND VGND VPWR VPWR _1495_/B sky130_fd_sc_hd__nor2_1
X_2394_ clkload6/A _2394_/D fanout143/X VGND VGND VPWR VPWR _2394_/Q sky130_fd_sc_hd__dfrtp_1
X_1414_ _2332_/A _1414_/B VGND VGND VPWR VPWR _1414_/Y sky130_fd_sc_hd__nand2_1
X_1345_ _1340_/Y _1341_/Y _1342_/Y _1343_/X _1485_/B VGND VGND VPWR VPWR _1357_/A
+ sky130_fd_sc_hd__a311o_1
XFILLER_51_233 VGND VGND VPWR VPWR sky130_fd_sc_hd__decap_12
XFILLER_36_274 VGND VGND VPWR VPWR sky130_fd_sc_hd__decap_8
XFILLER_11_108 VGND VGND VPWR VPWR sky130_fd_sc_hd__decap_4
XFILLER_22_59 VGND VGND VPWR VPWR sky130_fd_sc_hd__fill_1
Xfanout132 _2427_/Q VGND VGND VPWR VPWR _2176_/A sky130_fd_sc_hd__clkdlybuf4s50_1
Xfanout165 fanout173/X VGND VGND VPWR VPWR fanout165/X sky130_fd_sc_hd__clkdlybuf4s50_1
Xfanout121 _2433_/Q VGND VGND VPWR VPWR _2305_/B sky130_fd_sc_hd__clkdlybuf4s50_1
Xfanout143 fanout145/X VGND VGND VPWR VPWR fanout143/X sky130_fd_sc_hd__clkdlybuf4s50_1
Xfanout110 _2316_/B VGND VGND VPWR VPWR _2158_/B sky130_fd_sc_hd__clkdlybuf4s50_1
Xfanout187 fanout187/A VGND VGND VPWR VPWR fanout187/X sky130_fd_sc_hd__clkdlybuf4s50_1
Xfanout176 fanout182/X VGND VGND VPWR VPWR fanout176/X sky130_fd_sc_hd__clkdlybuf4s50_1
XFILLER_47_67 VGND VGND VPWR VPWR sky130_fd_sc_hd__fill_2
XTAP_TAPCELL_ROW_6_178 VGND VPWR sky130_fd_sc_hd__tapvpwrvgnd_1
XFILLER_42_244 VGND VGND VPWR VPWR sky130_fd_sc_hd__decap_8
XFILLER_12_70 VGND VGND VPWR VPWR sky130_fd_sc_hd__fill_1
XFILLER_33_288 VGND VGND VPWR VPWR sky130_fd_sc_hd__fill_1
XFILLER_33_266 VGND VGND VPWR VPWR sky130_fd_sc_hd__decap_6
XFILLER_33_244 VGND VGND VPWR VPWR sky130_fd_sc_hd__decap_3
XTAP_TAPCELL_ROW_28_291 VGND VPWR sky130_fd_sc_hd__tapvpwrvgnd_1
X_1963_ _1963_/A _1966_/B VGND VGND VPWR VPWR _1963_/Y sky130_fd_sc_hd__nand2_1
X_1894_ _1894_/A _1969_/B VGND VGND VPWR VPWR _1894_/Y sky130_fd_sc_hd__nand2_1
X_2446_ clkload8/A _2446_/D load_slew172/X VGND VGND VPWR VPWR _2446_/Q sky130_fd_sc_hd__dfrtp_1
X_2515_ clkload2/A _2515_/D fanout151/X VGND VGND VPWR VPWR _2515_/Q sky130_fd_sc_hd__dfrtp_1
X_1259_ _1259_/A VGND VGND VPWR VPWR _1259_/Y sky130_fd_sc_hd__inv_1
XFILLER_68_141 VGND VGND VPWR VPWR sky130_fd_sc_hd__fill_1
X_2377_ _2379_/A _2444_/Q VGND VGND VPWR VPWR _2377_/Y sky130_fd_sc_hd__nand2_1
X_1328_ _1486_/A _2230_/A VGND VGND VPWR VPWR _1329_/B sky130_fd_sc_hd__nor2_1
XFILLER_59_163 VGND VGND VPWR VPWR sky130_fd_sc_hd__fill_1
XFILLER_58_66 VGND VGND VPWR VPWR sky130_fd_sc_hd__decap_3
XFILLER_58_44 VGND VGND VPWR VPWR sky130_fd_sc_hd__fill_2
XFILLER_30_203 VGND VGND VPWR VPWR sky130_fd_sc_hd__fill_1
XFILLER_15_200 VGND VGND VPWR VPWR sky130_fd_sc_hd__decap_4
XFILLER_30_247 VGND VGND VPWR VPWR sky130_fd_sc_hd__fill_1
XTAP_TAPCELL_ROW_25_272 VGND VPWR sky130_fd_sc_hd__tapvpwrvgnd_1
X_2231_ _2479_/Q _2232_/B VGND VGND VPWR VPWR _2231_/Y sky130_fd_sc_hd__nand2_1
X_2300_ fanout3/X _2299_/Y _1519_/A _1466_/B VGND VGND VPWR VPWR _2432_/D sky130_fd_sc_hd__a2bb2oi_1
XFILLER_65_177 VGND VGND VPWR VPWR sky130_fd_sc_hd__decap_8
X_2093_ _2082_/A _2360_/A _1565_/Y VGND VGND VPWR VPWR _2096_/B sky130_fd_sc_hd__o21ai_0
X_2162_ _2157_/Y _2158_/Y _2159_/Y _2155_/Y VGND VGND VPWR VPWR _2162_/Y sky130_fd_sc_hd__a31oi_1
XFILLER_17_3 VGND VGND VPWR VPWR sky130_fd_sc_hd__fill_1
X_1877_ _1951_/B hold377/X _1876_/Y VGND VGND VPWR VPWR _2525_/D sky130_fd_sc_hd__o21ai_0
X_1946_ _1945_/B _1944_/Y _1945_/Y VGND VGND VPWR VPWR _1946_/Y sky130_fd_sc_hd__o21ai_0
XFILLER_56_100 VGND VGND VPWR VPWR sky130_fd_sc_hd__decap_4
X_2429_ clkload3/A _2429_/D _2429_/SET_B VGND VGND VPWR VPWR _2429_/Q sky130_fd_sc_hd__dfstp_2
XFILLER_56_188 VGND VGND VPWR VPWR sky130_fd_sc_hd__decap_8
XTAP_TAPCELL_ROW_39_342 VGND VPWR sky130_fd_sc_hd__tapvpwrvgnd_1
XFILLER_12_214 VGND VGND VPWR VPWR sky130_fd_sc_hd__fill_1
XFILLER_12_247 VGND VGND VPWR VPWR sky130_fd_sc_hd__decap_4
XFILLER_47_188 VGND VGND VPWR VPWR sky130_fd_sc_hd__fill_1
XFILLER_18_80 VGND VGND VPWR VPWR sky130_fd_sc_hd__fill_1
X_1800_ _1805_/D _1800_/B VGND VGND VPWR VPWR _2498_/D sky130_fd_sc_hd__nor2_1
XFILLER_62_158 VGND VGND VPWR VPWR sky130_fd_sc_hd__fill_1
Xhold229 _1964_/Y VGND VGND VPWR VPWR _2554_/D sky130_fd_sc_hd__dlygate4sd3_1
Xhold207 _2533_/Q VGND VGND VPWR VPWR _1900_/A sky130_fd_sc_hd__dlygate4sd3_1
X_1662_ _2476_/Q _1663_/C VGND VGND VPWR VPWR _1685_/B sky130_fd_sc_hd__nand2_1
Xhold218 _2542_/Q VGND VGND VPWR VPWR _1927_/A sky130_fd_sc_hd__dlygate4sd3_1
XFILLER_7_251 VGND VGND VPWR VPWR sky130_fd_sc_hd__decap_3
X_1731_ _2453_/Q _2395_/Q VGND VGND VPWR VPWR _2126_/C sky130_fd_sc_hd__nor2_1
X_2214_ _2478_/Q _2215_/B VGND VGND VPWR VPWR _2216_/A sky130_fd_sc_hd__nor2_1
X_1593_ _1603_/A _1593_/B VGND VGND VPWR VPWR _2628_/D sky130_fd_sc_hd__nor2_1
XPHY_EDGE_ROW_37_Left_108 VGND VGND VPWR VPWR sky130_fd_sc_hd__decap_3
Xload_slew154 fanout153/X VGND VGND VPWR VPWR load_slew154/X sky130_fd_sc_hd__buf_4
X_2076_ _2466_/Q _2408_/Q _2076_/S VGND VGND VPWR VPWR _2408_/D sky130_fd_sc_hd__mux2_1
XFILLER_53_169 VGND VGND VPWR VPWR sky130_fd_sc_hd__decap_12
X_2145_ _2257_/B _1688_/A _2200_/A _2198_/A _2144_/Y VGND VGND VPWR VPWR _2145_/Y
+ sky130_fd_sc_hd__a221oi_1
XPHY_EDGE_ROW_46_Left_117 VGND VGND VPWR VPWR sky130_fd_sc_hd__decap_3
X_1929_ _2542_/Q _2568_/Q _1932_/S VGND VGND VPWR VPWR _1929_/Y sky130_fd_sc_hd__mux2i_1
XFILLER_14_27 VGND VGND VPWR VPWR sky130_fd_sc_hd__fill_1
XFILLER_14_38 VGND VGND VPWR VPWR sky130_fd_sc_hd__decap_6
XPHY_EDGE_ROW_55_Left_126 VGND VGND VPWR VPWR sky130_fd_sc_hd__decap_3
XFILLER_29_111 VGND VGND VPWR VPWR sky130_fd_sc_hd__fill_1
XPHY_EDGE_ROW_64_Left_135 VGND VGND VPWR VPWR sky130_fd_sc_hd__decap_3
XFILLER_55_45 VGND VGND VPWR VPWR sky130_fd_sc_hd__fill_2
XTAP_TAPCELL_ROW_42_359 VGND VPWR sky130_fd_sc_hd__tapvpwrvgnd_1
XFILLER_4_221 VGND VGND VPWR VPWR sky130_fd_sc_hd__decap_3
XTAP_TAPCELL_ROW_10_201 VGND VPWR sky130_fd_sc_hd__tapvpwrvgnd_1
XFILLER_4_287 VGND VGND VPWR VPWR sky130_fd_sc_hd__fill_2
XFILLER_20_92 VGND VGND VPWR VPWR sky130_fd_sc_hd__fill_1
XFILLER_35_169 VGND VGND VPWR VPWR sky130_fd_sc_hd__decap_8
XFILLER_50_139 VGND VGND VPWR VPWR sky130_fd_sc_hd__fill_1
XTAP_TAPCELL_ROW_33_315 VGND VPWR sky130_fd_sc_hd__tapvpwrvgnd_1
X_1645_ _1247_/Y _1558_/Y _2380_/S VGND VGND VPWR VPWR _2466_/D sky130_fd_sc_hd__mux2i_1
X_1576_ _2622_/Q _1578_/C VGND VGND VPWR VPWR _1577_/B sky130_fd_sc_hd__xnor2_1
X_1714_ _2454_/Q _2396_/Q _2453_/Q _2395_/Q VGND VGND VPWR VPWR _1743_/A sky130_fd_sc_hd__a22o_1
XTAP_TAPCELL_ROW_56_429 VGND VPWR sky130_fd_sc_hd__tapvpwrvgnd_1
X_2128_ _2128_/A _2128_/B _2128_/C VGND VGND VPWR VPWR _2129_/C sky130_fd_sc_hd__nand3_1
X_2059_ _2449_/Q hold361/X _2060_/S VGND VGND VPWR VPWR _2391_/D sky130_fd_sc_hd__mux2_1
XFILLER_41_47 VGND VGND VPWR VPWR sky130_fd_sc_hd__fill_1
XFILLER_66_11 VGND VGND VPWR VPWR sky130_fd_sc_hd__decap_3
XFILLER_17_169 VGND VGND VPWR VPWR sky130_fd_sc_hd__fill_2
XTAP_TAPCELL_ROW_70_498 VGND VPWR sky130_fd_sc_hd__tapvpwrvgnd_1
XFILLER_40_194 VGND VGND VPWR VPWR sky130_fd_sc_hd__fill_2
X_1430_ _1430_/A _1430_/B VGND VGND VPWR VPWR _1433_/B sky130_fd_sc_hd__xnor2_1
X_1292_ _1283_/Y _1284_/Y _1291_/Y VGND VGND VPWR VPWR _1292_/X sky130_fd_sc_hd__a21o_1
XFILLER_48_250 VGND VGND VPWR VPWR sky130_fd_sc_hd__fill_2
X_1361_ _2158_/B _2331_/B VGND VGND VPWR VPWR _1364_/B sky130_fd_sc_hd__xor2_1
XTAP_TAPCELL_ROW_61_454 VGND VPWR sky130_fd_sc_hd__tapvpwrvgnd_1
X_1559_ _2167_/A _1466_/B _1558_/Y _1540_/X _1454_/X VGND VGND VPWR VPWR _1559_/Y
+ sky130_fd_sc_hd__o32ai_1
X_1628_ _1227_/Y _1627_/Y _1628_/S VGND VGND VPWR VPWR _2457_/D sky130_fd_sc_hd__mux2i_1
XFILLER_54_253 VGND VGND VPWR VPWR sky130_fd_sc_hd__decap_6
XFILLER_39_261 VGND VGND VPWR VPWR sky130_fd_sc_hd__decap_4
XFILLER_39_250 VGND VGND VPWR VPWR sky130_fd_sc_hd__decap_4
XTAP_TAPCELL_ROW_52_410 VGND VPWR sky130_fd_sc_hd__tapvpwrvgnd_1
XFILLER_60_234 VGND VGND VPWR VPWR sky130_fd_sc_hd__decap_6
XFILLER_60_267 VGND VGND VPWR VPWR sky130_fd_sc_hd__fill_2
X_2600_ clkload9/A _2600_/D load_slew168/X VGND VGND VPWR VPWR _2600_/Q sky130_fd_sc_hd__dfrtp_1
XFILLER_9_187 VGND VGND VPWR VPWR sky130_fd_sc_hd__decap_12
X_2462_ clkload9/A _2462_/D load_slew166/X VGND VGND VPWR VPWR _2462_/Q sky130_fd_sc_hd__dfrtp_1
X_2531_ _2606_/CLK _2531_/D load_slew170/X VGND VGND VPWR VPWR _2531_/Q sky130_fd_sc_hd__dfrtp_1
X_2393_ clkload6/A _2393_/D fanout148/X VGND VGND VPWR VPWR _2393_/Q sky130_fd_sc_hd__dfrtp_1
X_1413_ _2158_/B _1413_/B _1413_/C VGND VGND VPWR VPWR _1414_/B sky130_fd_sc_hd__nor3_1
X_1275_ _1275_/A _1275_/B VGND VGND VPWR VPWR _1275_/Y sky130_fd_sc_hd__xnor2_1
X_1344_ _2159_/A _1484_/A VGND VGND VPWR VPWR _1485_/B sky130_fd_sc_hd__nor2_1
XFILLER_28_209 VGND VGND VPWR VPWR sky130_fd_sc_hd__decap_12
XFILLER_51_245 VGND VGND VPWR VPWR sky130_fd_sc_hd__fill_2
XFILLER_51_223 VGND VGND VPWR VPWR sky130_fd_sc_hd__fill_1
XFILLER_22_27 VGND VGND VPWR VPWR sky130_fd_sc_hd__fill_1
Xfanout188 fanout190/X VGND VGND VPWR VPWR fanout188/X sky130_fd_sc_hd__clkdlybuf4s50_1
Xfanout133 _2427_/Q VGND VGND VPWR VPWR _2213_/B sky130_fd_sc_hd__clkdlybuf4s50_1
Xfanout155 fanout156/X VGND VGND VPWR VPWR fanout155/X sky130_fd_sc_hd__clkdlybuf4s50_1
XTAP_TAPCELL_ROW_6_179 VGND VPWR sky130_fd_sc_hd__tapvpwrvgnd_1
Xfanout111 _2437_/Q VGND VGND VPWR VPWR _2316_/B sky130_fd_sc_hd__clkdlybuf4s50_1
Xfanout100 _2365_/B1 VGND VGND VPWR VPWR _1557_/A sky130_fd_sc_hd__clkdlybuf4s50_1
Xfanout122 _2432_/Q VGND VGND VPWR VPWR _2287_/B sky130_fd_sc_hd__clkdlybuf4s50_1
XFILLER_47_57 VGND VGND VPWR VPWR sky130_fd_sc_hd__fill_2
XPHY_EDGE_ROW_29_Right_29 VGND VGND VPWR VPWR sky130_fd_sc_hd__decap_3
XFILLER_27_220 VGND VGND VPWR VPWR sky130_fd_sc_hd__decap_4
XPHY_EDGE_ROW_38_Right_38 VGND VGND VPWR VPWR sky130_fd_sc_hd__decap_3
XFILLER_6_124 VGND VGND VPWR VPWR sky130_fd_sc_hd__fill_2
XFILLER_8_29 VGND VGND VPWR VPWR sky130_fd_sc_hd__fill_2
XPHY_EDGE_ROW_47_Right_47 VGND VGND VPWR VPWR sky130_fd_sc_hd__decap_3
XFILLER_18_220 VGND VGND VPWR VPWR sky130_fd_sc_hd__decap_12
X_1962_ _1960_/A _2579_/Q _1965_/S VGND VGND VPWR VPWR _1962_/Y sky130_fd_sc_hd__mux2i_1
XPHY_EDGE_ROW_56_Right_56 VGND VGND VPWR VPWR sky130_fd_sc_hd__decap_3
X_1893_ _1891_/A hold375/X _1902_/S VGND VGND VPWR VPWR _1893_/Y sky130_fd_sc_hd__mux2i_1
XPHY_EDGE_ROW_65_Right_65 VGND VGND VPWR VPWR sky130_fd_sc_hd__decap_3
X_2445_ clkload8/A _2445_/D fanout169/X VGND VGND VPWR VPWR _2445_/Q sky130_fd_sc_hd__dfrtp_1
X_2514_ clkload8/A _2514_/D fanout167/X VGND VGND VPWR VPWR _2514_/Q sky130_fd_sc_hd__dfrtp_1
XFILLER_5_190 VGND VGND VPWR VPWR sky130_fd_sc_hd__decap_12
X_2376_ _1221_/Y _2375_/C _2375_/Y VGND VGND VPWR VPWR _2442_/D sky130_fd_sc_hd__o21ai_0
X_1327_ _1339_/A _1339_/B VGND VGND VPWR VPWR _1331_/A sky130_fd_sc_hd__nand2_1
X_1258_ _2418_/Q VGND VGND VPWR VPWR _1550_/A sky130_fd_sc_hd__inv_1
XFILLER_24_201 VGND VGND VPWR VPWR sky130_fd_sc_hd__fill_1
XFILLER_24_212 VGND VGND VPWR VPWR sky130_fd_sc_hd__decap_8
XFILLER_3_149 VGND VGND VPWR VPWR sky130_fd_sc_hd__decap_3
XFILLER_58_23 VGND VGND VPWR VPWR sky130_fd_sc_hd__decap_4
XFILLER_30_226 VGND VGND VPWR VPWR sky130_fd_sc_hd__fill_1
XTAP_TAPCELL_ROW_2_160 VGND VPWR sky130_fd_sc_hd__tapvpwrvgnd_1
XFILLER_15_212 VGND VGND VPWR VPWR sky130_fd_sc_hd__fill_1
XFILLER_15_223 VGND VGND VPWR VPWR sky130_fd_sc_hd__fill_1
XTAP_TAPCELL_ROW_25_273 VGND VPWR sky130_fd_sc_hd__tapvpwrvgnd_1
X_2230_ _2230_/A _2230_/B VGND VGND VPWR VPWR _2232_/B sky130_fd_sc_hd__xnor2_1
XFILLER_65_167 VGND VGND VPWR VPWR sky130_fd_sc_hd__fill_1
XTAP_TAPCELL_ROW_48_387 VGND VPWR sky130_fd_sc_hd__tapvpwrvgnd_1
XFILLER_0_85 VGND VGND VPWR VPWR sky130_fd_sc_hd__decap_12
X_2092_ _1560_/B _2168_/B VGND VGND VPWR VPWR _2092_/Y sky130_fd_sc_hd__nand2b_1
X_2161_ _2331_/A _2289_/A _2155_/Y _2157_/Y _2160_/Y VGND VGND VPWR VPWR wire37/A
+ sky130_fd_sc_hd__a2111oi_0
X_1945_ _1945_/A _1945_/B VGND VGND VPWR VPWR _1945_/Y sky130_fd_sc_hd__nand2_1
X_1876_ _1876_/A _1951_/B VGND VGND VPWR VPWR _1876_/Y sky130_fd_sc_hd__nand2_1
X_2428_ clkload3/A _2428_/D fanout183/X VGND VGND VPWR VPWR _2428_/Q sky130_fd_sc_hd__dfstp_2
XTAP_TAPCELL_ROW_39_343 VGND VPWR sky130_fd_sc_hd__tapvpwrvgnd_1
X_2359_ _2316_/B _2318_/A _2359_/S VGND VGND VPWR VPWR _2360_/B sky130_fd_sc_hd__mux2i_1
XFILLER_12_226 VGND VGND VPWR VPWR sky130_fd_sc_hd__fill_1
Xhold208 _1901_/Y VGND VGND VPWR VPWR _2533_/D sky130_fd_sc_hd__dlygate4sd3_1
X_1661_ _1680_/A _1680_/B VGND VGND VPWR VPWR _1663_/C sky130_fd_sc_hd__nor2_1
X_1592_ _2628_/Q _1594_/C VGND VGND VPWR VPWR _1593_/B sky130_fd_sc_hd__xnor2_1
Xhold219 _2538_/Q VGND VGND VPWR VPWR _1915_/A sky130_fd_sc_hd__dlygate4sd3_1
XFILLER_11_281 VGND VGND VPWR VPWR sky130_fd_sc_hd__decap_8
X_1730_ _1726_/Y _2126_/A _2126_/B _1729_/Y VGND VGND VPWR VPWR _1730_/X sky130_fd_sc_hd__o31a_1
Xload_slew177 fanout176/X VGND VGND VPWR VPWR load_slew177/X sky130_fd_sc_hd__buf_4
X_2144_ _2241_/B _2477_/Q _2142_/Y _2143_/Y _2476_/Q _1303_/A VGND VGND VPWR VPWR
+ _2144_/Y sky130_fd_sc_hd__a222oi_1
X_2213_ _2430_/Q _2213_/B VGND VGND VPWR VPWR _2215_/B sky130_fd_sc_hd__xnor2_1
Xload_slew166 fanout165/X VGND VGND VPWR VPWR load_slew166/X sky130_fd_sc_hd__clkbuf_4
Xload_slew144 fanout143/X VGND VGND VPWR VPWR load_slew144/X sky130_fd_sc_hd__buf_4
X_2075_ _2465_/Q _2407_/Q _2076_/S VGND VGND VPWR VPWR _2407_/D sky130_fd_sc_hd__mux2_1
XFILLER_30_38 VGND VGND VPWR VPWR sky130_fd_sc_hd__fill_2
XFILLER_30_27 VGND VGND VPWR VPWR sky130_fd_sc_hd__fill_1
X_1859_ _1930_/B _1857_/Y _1858_/Y VGND VGND VPWR VPWR _2519_/D sky130_fd_sc_hd__o21ai_0
X_1928_ _1930_/B _1926_/Y _1927_/Y VGND VGND VPWR VPWR _2542_/D sky130_fd_sc_hd__o21ai_0
XFILLER_69_281 VGND VGND VPWR VPWR sky130_fd_sc_hd__decap_8
XTAP_TAPCELL_ROW_67_482 VGND VPWR sky130_fd_sc_hd__tapvpwrvgnd_1
XFILLER_55_57 VGND VGND VPWR VPWR sky130_fd_sc_hd__fill_1
XFILLER_29_167 VGND VGND VPWR VPWR sky130_fd_sc_hd__fill_1
XFILLER_35_159 VGND VGND VPWR VPWR sky130_fd_sc_hd__fill_2
XTAP_TAPCELL_ROW_33_316 VGND VPWR sky130_fd_sc_hd__tapvpwrvgnd_1
X_1713_ _2125_/A VGND VGND VPWR VPWR _1755_/B sky130_fd_sc_hd__inv_1
X_1575_ _1977_/B _1578_/C _1575_/C VGND VGND VPWR VPWR _2621_/D sky130_fd_sc_hd__nor3_1
X_1644_ _1246_/Y _1643_/Y _2384_/S VGND VGND VPWR VPWR _2465_/D sky130_fd_sc_hd__mux2i_1
XFILLER_66_251 VGND VGND VPWR VPWR sky130_fd_sc_hd__fill_1
X_2127_ _2447_/Q _2389_/Q _2446_/Q _2388_/Q VGND VGND VPWR VPWR _2128_/C sky130_fd_sc_hd__nor4_1
XPHY_EDGE_ROW_16_Left_87 VGND VGND VPWR VPWR sky130_fd_sc_hd__decap_3
X_2058_ _2448_/Q hold368/X _2076_/S VGND VGND VPWR VPWR _2390_/D sky130_fd_sc_hd__mux2_1
XFILLER_1_225 VGND VGND VPWR VPWR sky130_fd_sc_hd__decap_8
XFILLER_66_78 VGND VGND VPWR VPWR sky130_fd_sc_hd__fill_1
XFILLER_17_104 VGND VGND VPWR VPWR sky130_fd_sc_hd__fill_1
XTAP_TAPCELL_ROW_70_499 VGND VPWR sky130_fd_sc_hd__tapvpwrvgnd_1
XFILLER_25_181 VGND VGND VPWR VPWR sky130_fd_sc_hd__decap_12
X_1360_ _2159_/A _1470_/C _1357_/Y VGND VGND VPWR VPWR _1371_/A sky130_fd_sc_hd__a21oi_1
X_1291_ _2475_/Q _1289_/X _1290_/Y _2474_/Q _1274_/Y VGND VGND VPWR VPWR _1291_/Y
+ sky130_fd_sc_hd__o32ai_1
XTAP_TAPCELL_ROW_61_455 VGND VPWR sky130_fd_sc_hd__tapvpwrvgnd_1
X_1558_ _2082_/A _2442_/Q VGND VGND VPWR VPWR _1558_/Y sky130_fd_sc_hd__nand2_1
X_1627_ _1627_/A _2458_/Q VGND VGND VPWR VPWR _1627_/Y sky130_fd_sc_hd__nand2_1
X_1489_ _1484_/A _1530_/A _1484_/B _2351_/A VGND VGND VPWR VPWR _1490_/B sky130_fd_sc_hd__o211ai_1
XFILLER_54_287 VGND VGND VPWR VPWR sky130_fd_sc_hd__fill_2
XFILLER_54_243 VGND VGND VPWR VPWR sky130_fd_sc_hd__fill_1
XTAP_TAPCELL_ROW_52_411 VGND VPWR sky130_fd_sc_hd__tapvpwrvgnd_1
XFILLER_52_58 VGND VGND VPWR VPWR sky130_fd_sc_hd__fill_1
XFILLER_22_151 VGND VGND VPWR VPWR sky130_fd_sc_hd__decap_4
XFILLER_7_3 VGND VGND VPWR VPWR sky130_fd_sc_hd__decap_8
Xhold380 _2590_/Q VGND VGND VPWR VPWR hold380/X sky130_fd_sc_hd__dlygate4sd3_1
XFILLER_60_224 VGND VGND VPWR VPWR sky130_fd_sc_hd__decap_4
XFILLER_13_140 VGND VGND VPWR VPWR sky130_fd_sc_hd__fill_1
X_2530_ clkload8/A _2530_/D load_slew170/X VGND VGND VPWR VPWR _2530_/Q sky130_fd_sc_hd__dfrtp_1
XFILLER_9_133 VGND VGND VPWR VPWR sky130_fd_sc_hd__decap_6
XFILLER_9_199 VGND VGND VPWR VPWR sky130_fd_sc_hd__decap_8
X_2461_ clkload9/A _2461_/D load_slew166/X VGND VGND VPWR VPWR _2461_/Q sky130_fd_sc_hd__dfrtp_1
X_2392_ _2592_/CLK _2392_/D load_slew154/X VGND VGND VPWR VPWR _2392_/Q sky130_fd_sc_hd__dfrtp_1
X_1412_ _1412_/A _1413_/C VGND VGND VPWR VPWR _1415_/B sky130_fd_sc_hd__or2_0
X_1343_ _2159_/A _1484_/A VGND VGND VPWR VPWR _1343_/X sky130_fd_sc_hd__and2_0
X_1274_ _1274_/A _1274_/B VGND VGND VPWR VPWR _1274_/Y sky130_fd_sc_hd__xnor2_1
Xwire36 wire36/A VGND VGND VPWR VPWR wire36/X sky130_fd_sc_hd__clkdlybuf4s25_1
XFILLER_36_287 VGND VGND VPWR VPWR sky130_fd_sc_hd__fill_2
Xfanout178 wire181/A VGND VGND VPWR VPWR fanout178/X sky130_fd_sc_hd__clkdlybuf4s50_1
Xfanout134 _2426_/Q VGND VGND VPWR VPWR _2198_/B sky130_fd_sc_hd__clkdlybuf4s50_1
XFILLER_47_47 VGND VGND VPWR VPWR sky130_fd_sc_hd__fill_1
Xfanout167 fanout173/X VGND VGND VPWR VPWR fanout167/X sky130_fd_sc_hd__clkdlybuf4s50_1
Xfanout101 _2365_/B1 VGND VGND VPWR VPWR _2173_/A sky130_fd_sc_hd__clkdlybuf4s50_1
Xfanout123 _2432_/Q VGND VGND VPWR VPWR _2242_/A sky130_fd_sc_hd__clkdlybuf4s50_1
Xfanout156 fanout192/X VGND VGND VPWR VPWR fanout156/X sky130_fd_sc_hd__clkdlybuf4s50_1
Xfanout145 fanout192/X VGND VGND VPWR VPWR fanout145/X sky130_fd_sc_hd__clkdlybuf4s50_1
Xfanout112 _2351_/A VGND VGND VPWR VPWR _2159_/A sky130_fd_sc_hd__clkdlybuf4s50_1
XFILLER_42_257 VGND VGND VPWR VPWR sky130_fd_sc_hd__fill_1
XPHY_EDGE_ROW_19_Left_90 VGND VGND VPWR VPWR sky130_fd_sc_hd__decap_3
XFILLER_18_232 VGND VGND VPWR VPWR sky130_fd_sc_hd__fill_2
XFILLER_18_243 VGND VGND VPWR VPWR sky130_fd_sc_hd__decap_8
X_1961_ _1966_/B _1959_/Y _1960_/Y VGND VGND VPWR VPWR _1961_/Y sky130_fd_sc_hd__o21ai_0
X_1892_ _1966_/B _1890_/Y _1891_/Y VGND VGND VPWR VPWR _1892_/Y sky130_fd_sc_hd__o21ai_0
X_2513_ clkload8/A _2513_/D load_slew170/X VGND VGND VPWR VPWR _2513_/Q sky130_fd_sc_hd__dfrtp_1
XFILLER_68_187 VGND VGND VPWR VPWR sky130_fd_sc_hd__fill_1
Xclkbuf_leaf_5_clk clkload0/A VGND VGND VPWR VPWR _2607_/CLK sky130_fd_sc_hd__clkbuf_16
X_2444_ _2606_/CLK _2444_/D fanout169/X VGND VGND VPWR VPWR _2444_/Q sky130_fd_sc_hd__dfrtp_1
X_1326_ _2272_/A _1486_/A VGND VGND VPWR VPWR _1339_/B sky130_fd_sc_hd__or2_0
X_2375_ _2379_/A _2375_/B _2375_/C VGND VGND VPWR VPWR _2375_/Y sky130_fd_sc_hd__nand3_1
X_1257_ _2417_/Q VGND VGND VPWR VPWR _1257_/Y sky130_fd_sc_hd__inv_1
XTAP_TAPCELL_ROW_2_161 VGND VPWR sky130_fd_sc_hd__tapvpwrvgnd_1
XPHY_EDGE_ROW_4_Left_75 VGND VGND VPWR VPWR sky130_fd_sc_hd__decap_3
XTAP_TAPCELL_ROW_25_274 VGND VPWR sky130_fd_sc_hd__tapvpwrvgnd_1
XFILLER_65_113 VGND VGND VPWR VPWR sky130_fd_sc_hd__fill_2
XFILLER_31_7 VGND VGND VPWR VPWR sky130_fd_sc_hd__fill_1
X_2160_ _2330_/B _2486_/Q _2158_/Y VGND VGND VPWR VPWR _2160_/Y sky130_fd_sc_hd__o21ai_0
XFILLER_65_135 VGND VGND VPWR VPWR sky130_fd_sc_hd__fill_2
XTAP_TAPCELL_ROW_48_388 VGND VPWR sky130_fd_sc_hd__tapvpwrvgnd_1
XFILLER_0_97 VGND VGND VPWR VPWR sky130_fd_sc_hd__decap_12
X_2091_ hold370/X _2078_/Y _2080_/Y _2090_/X VGND VGND VPWR VPWR _2413_/D sky130_fd_sc_hd__o2bb2ai_1
XTAP_TAPCELL_ROW_16_230 VGND VPWR sky130_fd_sc_hd__tapvpwrvgnd_1
X_1875_ hold376/X _2598_/Q _1917_/S VGND VGND VPWR VPWR _1875_/Y sky130_fd_sc_hd__mux2i_1
X_1944_ _1942_/A _2573_/Q _1944_/S VGND VGND VPWR VPWR _1944_/Y sky130_fd_sc_hd__mux2i_1
XFILLER_21_216 VGND VGND VPWR VPWR sky130_fd_sc_hd__fill_1
X_2427_ _2633_/CLK _2427_/D fanout187/A VGND VGND VPWR VPWR _2427_/Q sky130_fd_sc_hd__dfstp_2
XFILLER_0_109 VGND VGND VPWR VPWR sky130_fd_sc_hd__decap_3
X_1309_ _2230_/A _2255_/A VGND VGND VPWR VPWR _1311_/A sky130_fd_sc_hd__xnor2_1
XTAP_TAPCELL_ROW_39_344 VGND VPWR sky130_fd_sc_hd__tapvpwrvgnd_1
X_2358_ _2351_/B _2356_/Y _2357_/Y VGND VGND VPWR VPWR _2358_/Y sky130_fd_sc_hd__a21oi_1
X_2289_ _2289_/A _2289_/B VGND VGND VPWR VPWR _2290_/C sky130_fd_sc_hd__xnor2_1
XFILLER_28_27 VGND VGND VPWR VPWR sky130_fd_sc_hd__fill_1
X_1660_ _2474_/Q _1678_/B VGND VGND VPWR VPWR _1680_/B sky130_fd_sc_hd__nand2_1
Xhold209 _2555_/Q VGND VGND VPWR VPWR _1966_/A sky130_fd_sc_hd__dlygate4sd3_1
X_1591_ _1603_/A _1594_/C _1591_/C VGND VGND VPWR VPWR _2627_/D sky130_fd_sc_hd__nor3_1
Xload_slew189 fanout188/X VGND VGND VPWR VPWR fanout187/A sky130_fd_sc_hd__buf_4
X_2143_ _2230_/B _2201_/C _1680_/A _2213_/B VGND VGND VPWR VPWR _2143_/Y sky130_fd_sc_hd__a22oi_1
X_2212_ _2257_/B _2212_/B VGND VGND VPWR VPWR _2234_/A sky130_fd_sc_hd__nor2_1
Xload_slew81 _1672_/B VGND VGND VPWR VPWR _1466_/B sky130_fd_sc_hd__clkbuf_4
Xload_slew70 _1974_/S VGND VGND VPWR VPWR _1971_/S sky130_fd_sc_hd__clkbuf_4
X_2074_ _2464_/Q _2406_/Q _2074_/S VGND VGND VPWR VPWR _2406_/D sky130_fd_sc_hd__mux2_1
Xfanout3 _2136_/Y VGND VGND VPWR VPWR fanout3/X sky130_fd_sc_hd__clkdlybuf4s50_1
X_1858_ _1858_/A _1930_/B VGND VGND VPWR VPWR _1858_/Y sky130_fd_sc_hd__nand2_1
X_1927_ _1927_/A _1930_/B VGND VGND VPWR VPWR _1927_/Y sky130_fd_sc_hd__nand2_1
X_1789_ _1789_/A _1789_/B VGND VGND VPWR VPWR _1789_/X sky130_fd_sc_hd__xor2_1
XFILLER_39_48 VGND VGND VPWR VPWR sky130_fd_sc_hd__decap_4
XFILLER_39_15 VGND VGND VPWR VPWR sky130_fd_sc_hd__fill_1
XTAP_TAPCELL_ROW_67_483 VGND VPWR sky130_fd_sc_hd__tapvpwrvgnd_1
XFILLER_55_69 VGND VGND VPWR VPWR sky130_fd_sc_hd__decap_3
XFILLER_29_157 VGND VGND VPWR VPWR sky130_fd_sc_hd__decap_3
X_1643_ _2379_/A _2466_/Q VGND VGND VPWR VPWR _1643_/Y sky130_fd_sc_hd__nand2_1
X_1712_ _2459_/Q _2401_/Q VGND VGND VPWR VPWR _2125_/A sky130_fd_sc_hd__nor2_1
XFILLER_58_208 VGND VGND VPWR VPWR sky130_fd_sc_hd__decap_6
X_1574_ _2620_/Q _1573_/C _2621_/Q VGND VGND VPWR VPWR _1575_/C sky130_fd_sc_hd__a21oi_1
XFILLER_6_74 VGND VGND VPWR VPWR sky130_fd_sc_hd__fill_1
X_2057_ _2447_/Q _2389_/Q _2060_/S VGND VGND VPWR VPWR _2389_/D sky130_fd_sc_hd__mux2_1
X_2126_ _2126_/A _2126_/B _2126_/C _2126_/D VGND VGND VPWR VPWR _2129_/B sky130_fd_sc_hd__nand4_1
XFILLER_57_252 VGND VGND VPWR VPWR sky130_fd_sc_hd__fill_1
XFILLER_25_193 VGND VGND VPWR VPWR sky130_fd_sc_hd__decap_4
XFILLER_40_141 VGND VGND VPWR VPWR sky130_fd_sc_hd__fill_1
XFILLER_15_83 VGND VGND VPWR VPWR sky130_fd_sc_hd__decap_3
X_1290_ _1289_/A _1289_/C _1289_/B VGND VGND VPWR VPWR _1290_/Y sky130_fd_sc_hd__a21oi_1
XFILLER_0_281 VGND VGND VPWR VPWR sky130_fd_sc_hd__decap_8
XTAP_TAPCELL_ROW_61_456 VGND VPWR sky130_fd_sc_hd__tapvpwrvgnd_1
XFILLER_31_185 VGND VGND VPWR VPWR sky130_fd_sc_hd__decap_3
XFILLER_31_174 VGND VGND VPWR VPWR sky130_fd_sc_hd__fill_1
X_1626_ _1228_/Y _1625_/Y _1628_/S VGND VGND VPWR VPWR _2456_/D sky130_fd_sc_hd__mux2i_1
X_1557_ _1557_/A _2096_/A _1560_/B _2168_/B VGND VGND VPWR VPWR _1563_/B sky130_fd_sc_hd__nand4_1
X_1488_ _1488_/A _1490_/A VGND VGND VPWR VPWR _1488_/Y sky130_fd_sc_hd__xnor2_1
X_2109_ _2105_/A _2108_/B _2108_/C _1257_/Y VGND VGND VPWR VPWR _2109_/X sky130_fd_sc_hd__a31o_1
XFILLER_52_37 VGND VGND VPWR VPWR sky130_fd_sc_hd__decap_8
XFILLER_22_141 VGND VGND VPWR VPWR sky130_fd_sc_hd__decap_4
Xhold370 _2413_/Q VGND VGND VPWR VPWR hold370/X sky130_fd_sc_hd__dlygate4sd3_1
Xhold381 _2441_/Q VGND VGND VPWR VPWR hold381/X sky130_fd_sc_hd__dlygate4sd3_1
X_2460_ clkload9/A _2460_/D load_slew166/X VGND VGND VPWR VPWR _2460_/Q sky130_fd_sc_hd__dfrtp_1
X_1273_ _2176_/A _1391_/B VGND VGND VPWR VPWR _1274_/B sky130_fd_sc_hd__xor2_1
X_1411_ _2159_/A _2331_/B VGND VGND VPWR VPWR _1413_/C sky130_fd_sc_hd__and2_0
X_2391_ clkload2/A _2391_/D load_slew154/X VGND VGND VPWR VPWR _2391_/Q sky130_fd_sc_hd__dfrtp_1
X_1342_ _1484_/A _2257_/A _2272_/A VGND VGND VPWR VPWR _1342_/Y sky130_fd_sc_hd__o21ai_0
XFILLER_51_225 VGND VGND VPWR VPWR sky130_fd_sc_hd__fill_1
Xwire59 wire60/X VGND VGND VPWR VPWR wire59/X sky130_fd_sc_hd__clkbuf_1
Xwire37 wire37/A VGND VGND VPWR VPWR wire37/X sky130_fd_sc_hd__clkdlybuf4s25_1
XFILLER_51_258 VGND VGND VPWR VPWR sky130_fd_sc_hd__fill_2
XFILLER_22_29 VGND VGND VPWR VPWR sky130_fd_sc_hd__fill_2
Xfanout113 _2436_/Q VGND VGND VPWR VPWR _2351_/A sky130_fd_sc_hd__clkdlybuf4s50_1
Xfanout102 _2608_/Q VGND VGND VPWR VPWR _2365_/B1 sky130_fd_sc_hd__clkdlybuf4s50_1
X_1609_ _1627_/A _2449_/Q VGND VGND VPWR VPWR _1609_/Y sky130_fd_sc_hd__nand2_1
X_2589_ clkload2/A _2589_/D fanout151/X VGND VGND VPWR VPWR _2589_/Q sky130_fd_sc_hd__dfrtp_1
Xfanout135 _2426_/Q VGND VGND VPWR VPWR _1391_/B sky130_fd_sc_hd__clkdlybuf4s50_1
Xfanout124 _2230_/A VGND VGND VPWR VPWR _2283_/A sky130_fd_sc_hd__clkdlybuf4s50_1
Xfanout146 fanout148/X VGND VGND VPWR VPWR fanout146/X sky130_fd_sc_hd__clkdlybuf4s50_1
Xfanout157 fanout157/A VGND VGND VPWR VPWR fanout157/X sky130_fd_sc_hd__clkdlybuf4s50_1
XFILLER_42_236 VGND VGND VPWR VPWR sky130_fd_sc_hd__fill_1
XFILLER_27_288 VGND VGND VPWR VPWR sky130_fd_sc_hd__fill_1
XFILLER_50_280 VGND VGND VPWR VPWR sky130_fd_sc_hd__fill_1
XFILLER_33_236 VGND VGND VPWR VPWR sky130_fd_sc_hd__decap_8
XFILLER_33_203 VGND VGND VPWR VPWR sky130_fd_sc_hd__decap_4
X_1960_ _1960_/A _1966_/B VGND VGND VPWR VPWR _1960_/Y sky130_fd_sc_hd__nand2_1
XFILLER_53_80 VGND VGND VPWR VPWR sky130_fd_sc_hd__decap_4
X_1891_ _1891_/A _1969_/B VGND VGND VPWR VPWR _1891_/Y sky130_fd_sc_hd__nand2_1
XFILLER_33_258 VGND VGND VPWR VPWR sky130_fd_sc_hd__fill_1
XFILLER_52_3 VGND VGND VPWR VPWR sky130_fd_sc_hd__decap_4
X_2512_ _2606_/CLK _2512_/D load_slew170/X VGND VGND VPWR VPWR _2512_/Q sky130_fd_sc_hd__dfrtp_1
X_2443_ _2606_/CLK _2443_/D fanout169/X VGND VGND VPWR VPWR _2443_/Q sky130_fd_sc_hd__dfrtp_1
X_1256_ _2173_/A VGND VGND VPWR VPWR _1256_/Y sky130_fd_sc_hd__inv_1
X_1325_ _2272_/A _1486_/A VGND VGND VPWR VPWR _1485_/A sky130_fd_sc_hd__nor2_1
X_2374_ _1455_/Y _2373_/B _2373_/Y VGND VGND VPWR VPWR _2441_/D sky130_fd_sc_hd__o21ai_0
XPHY_EDGE_ROW_20_Left_91 VGND VGND VPWR VPWR sky130_fd_sc_hd__decap_3
XFILLER_59_111 VGND VGND VPWR VPWR sky130_fd_sc_hd__fill_1
XTAP_TAPCELL_ROW_25_275 VGND VPWR sky130_fd_sc_hd__tapvpwrvgnd_1
XFILLER_2_195 VGND VGND VPWR VPWR sky130_fd_sc_hd__fill_1
X_2090_ _2413_/Q _2090_/B VGND VGND VPWR VPWR _2090_/X sky130_fd_sc_hd__xor2_1
XFILLER_65_169 VGND VGND VPWR VPWR sky130_fd_sc_hd__decap_4
XTAP_TAPCELL_ROW_48_389 VGND VPWR sky130_fd_sc_hd__tapvpwrvgnd_1
XFILLER_0_65 VGND VGND VPWR VPWR sky130_fd_sc_hd__fill_2
XTAP_TAPCELL_ROW_16_231 VGND VPWR sky130_fd_sc_hd__tapvpwrvgnd_1
XFILLER_9_52 VGND VGND VPWR VPWR sky130_fd_sc_hd__fill_1
X_1943_ _1942_/B _1941_/Y _1942_/Y VGND VGND VPWR VPWR _2547_/D sky130_fd_sc_hd__o21ai_0
X_1874_ _1945_/B _1872_/Y _1873_/Y VGND VGND VPWR VPWR _2524_/D sky130_fd_sc_hd__o21ai_0
X_2426_ _2633_/CLK _2426_/D fanout187/X VGND VGND VPWR VPWR _2426_/Q sky130_fd_sc_hd__dfstp_2
XFILLER_56_169 VGND VGND VPWR VPWR sky130_fd_sc_hd__decap_3
XFILLER_56_125 VGND VGND VPWR VPWR sky130_fd_sc_hd__fill_2
X_1239_ _2445_/Q VGND VGND VPWR VPWR _1239_/Y sky130_fd_sc_hd__inv_1
XTAP_TAPCELL_ROW_39_345 VGND VPWR sky130_fd_sc_hd__tapvpwrvgnd_1
X_1308_ _2230_/A _2255_/A VGND VGND VPWR VPWR _1308_/Y sky130_fd_sc_hd__nand2_1
X_2357_ _2316_/B _2351_/B _2360_/A VGND VGND VPWR VPWR _2357_/Y sky130_fd_sc_hd__o21ai_0
X_2288_ _2483_/Q _2289_/B VGND VGND VPWR VPWR _2288_/Y sky130_fd_sc_hd__nand2_1
XFILLER_60_26 VGND VGND VPWR VPWR sky130_fd_sc_hd__fill_2
XFILLER_60_15 VGND VGND VPWR VPWR sky130_fd_sc_hd__decap_3
XTAP_TAPCELL_ROW_13_212 VGND VPWR sky130_fd_sc_hd__tapvpwrvgnd_1
XFILLER_50_70 VGND VGND VPWR VPWR sky130_fd_sc_hd__fill_2
X_1590_ _2626_/Q _1589_/C _2627_/Q VGND VGND VPWR VPWR _1591_/C sky130_fd_sc_hd__a21oi_1
Xload_slew179 fanout178/X VGND VGND VPWR VPWR _2494_/SET_B sky130_fd_sc_hd__clkbuf_4
X_2142_ _2213_/B _1680_/A _2191_/A _2141_/Y VGND VGND VPWR VPWR _2142_/Y sky130_fd_sc_hd__o22ai_1
X_2073_ _2463_/Q hold360/X _2074_/S VGND VGND VPWR VPWR _2405_/D sky130_fd_sc_hd__mux2_1
X_2211_ _2176_/A _2475_/Q _2286_/S VGND VGND VPWR VPWR _2211_/Y sky130_fd_sc_hd__mux2i_1
Xload_slew168 fanout167/X VGND VGND VPWR VPWR load_slew168/X sky130_fd_sc_hd__clkbuf_4
XFILLER_15_3 VGND VGND VPWR VPWR sky130_fd_sc_hd__fill_1
XTAP_TAPCELL_ROW_44_370 VGND VPWR sky130_fd_sc_hd__tapvpwrvgnd_1
X_1788_ _2465_/Q _2407_/Q _1788_/C VGND VGND VPWR VPWR _1789_/B sky130_fd_sc_hd__maj3_1
X_1857_ _2518_/Q _2592_/Q _1926_/S VGND VGND VPWR VPWR _1857_/Y sky130_fd_sc_hd__mux2i_1
X_1926_ _2541_/Q _2567_/Q _1926_/S VGND VGND VPWR VPWR _1926_/Y sky130_fd_sc_hd__mux2i_1
X_2409_ _2592_/CLK _2409_/D fanout148/X VGND VGND VPWR VPWR _2409_/Q sky130_fd_sc_hd__dfrtp_1
XTAP_TAPCELL_ROW_67_484 VGND VPWR sky130_fd_sc_hd__tapvpwrvgnd_1
XFILLER_55_37 VGND VGND VPWR VPWR sky130_fd_sc_hd__decap_4
XFILLER_44_139 VGND VGND VPWR VPWR sky130_fd_sc_hd__fill_1
XFILLER_29_169 VGND VGND VPWR VPWR sky130_fd_sc_hd__decap_6
XPHY_EDGE_ROW_33_Left_104 VGND VGND VPWR VPWR sky130_fd_sc_hd__decap_3
XPHY_EDGE_ROW_42_Left_113 VGND VGND VPWR VPWR sky130_fd_sc_hd__decap_3
XFILLER_4_213 VGND VGND VPWR VPWR sky130_fd_sc_hd__decap_8
XTAP_TAPCELL_ROW_58_440 VGND VPWR sky130_fd_sc_hd__tapvpwrvgnd_1
XFILLER_35_106 VGND VGND VPWR VPWR sky130_fd_sc_hd__decap_3
XPHY_EDGE_ROW_51_Left_122 VGND VGND VPWR VPWR sky130_fd_sc_hd__decap_3
X_1642_ _1245_/Y _1641_/Y _2384_/S VGND VGND VPWR VPWR _2464_/D sky130_fd_sc_hd__mux2i_1
X_1711_ _2123_/B _1756_/A VGND VGND VPWR VPWR _1749_/A sky130_fd_sc_hd__nand2_1
XPHY_EDGE_ROW_60_Left_131 VGND VGND VPWR VPWR sky130_fd_sc_hd__decap_3
X_1573_ _2621_/Q _2620_/Q _1573_/C VGND VGND VPWR VPWR _1578_/C sky130_fd_sc_hd__and3_1
XFILLER_66_253 VGND VGND VPWR VPWR sky130_fd_sc_hd__decap_6
X_2125_ _2125_/A _2125_/B _2125_/C _2125_/D VGND VGND VPWR VPWR _2129_/A sky130_fd_sc_hd__nand4_1
X_2056_ _2446_/Q _2388_/Q _2074_/S VGND VGND VPWR VPWR _2388_/D sky130_fd_sc_hd__mux2_1
XFILLER_19_191 VGND VGND VPWR VPWR sky130_fd_sc_hd__decap_12
X_1909_ _1909_/A _1909_/B VGND VGND VPWR VPWR _1909_/Y sky130_fd_sc_hd__nand2_1
XFILLER_66_58 VGND VGND VPWR VPWR sky130_fd_sc_hd__decap_12
XFILLER_66_25 VGND VGND VPWR VPWR sky130_fd_sc_hd__decap_3
XFILLER_40_197 VGND VGND VPWR VPWR sky130_fd_sc_hd__decap_3
XFILLER_63_278 VGND VGND VPWR VPWR sky130_fd_sc_hd__fill_2
XFILLER_63_223 VGND VGND VPWR VPWR sky130_fd_sc_hd__fill_1
XFILLER_48_253 VGND VGND VPWR VPWR sky130_fd_sc_hd__fill_2
XFILLER_48_242 VGND VGND VPWR VPWR sky130_fd_sc_hd__fill_1
XFILLER_16_161 VGND VGND VPWR VPWR sky130_fd_sc_hd__decap_6
X_1556_ _1556_/A _1556_/B wire59/X VGND VGND VPWR VPWR _2168_/B sky130_fd_sc_hd__nand3_1
X_1625_ _1627_/A _2457_/Q VGND VGND VPWR VPWR _1625_/Y sky130_fd_sc_hd__nand2_1
X_1487_ _2316_/B _1490_/A _1484_/B _1470_/B VGND VGND VPWR VPWR _1487_/Y sky130_fd_sc_hd__o211ai_1
X_2039_ _1224_/Y _2038_/B _2038_/Y VGND VGND VPWR VPWR _2601_/D sky130_fd_sc_hd__a21oi_1
X_2108_ _2108_/A _2108_/B _2108_/C VGND VGND VPWR VPWR _2108_/Y sky130_fd_sc_hd__nand3_1
XFILLER_22_197 VGND VGND VPWR VPWR sky130_fd_sc_hd__fill_1
Xhold360 _2405_/Q VGND VGND VPWR VPWR hold360/X sky130_fd_sc_hd__dlygate4sd3_1
Xhold371 _2403_/Q VGND VGND VPWR VPWR hold371/X sky130_fd_sc_hd__dlygate4sd3_1
XFILLER_60_259 VGND VGND VPWR VPWR sky130_fd_sc_hd__fill_1
XFILLER_42_60 VGND VGND VPWR VPWR sky130_fd_sc_hd__fill_1
XFILLER_13_153 VGND VGND VPWR VPWR sky130_fd_sc_hd__fill_1
XFILLER_26_83 VGND VGND VPWR VPWR sky130_fd_sc_hd__fill_1
X_1410_ _1412_/A _1415_/A VGND VGND VPWR VPWR _1413_/B sky130_fd_sc_hd__nor2_1
X_1272_ _2212_/B _2137_/A VGND VGND VPWR VPWR _1289_/A sky130_fd_sc_hd__nand2_1
X_1341_ _1341_/A _1341_/B VGND VGND VPWR VPWR _1341_/Y sky130_fd_sc_hd__nand2_1
X_2390_ clkload2/A _2390_/D load_slew154/X VGND VGND VPWR VPWR _2390_/Q sky130_fd_sc_hd__dfrtp_1
XTAP_TAPCELL_ROW_8_190 VGND VPWR sky130_fd_sc_hd__tapvpwrvgnd_1
XFILLER_36_212 VGND VGND VPWR VPWR sky130_fd_sc_hd__decap_6
Xwire16 wire16/A VGND VGND VPWR VPWR wire16/X sky130_fd_sc_hd__buf_1
Xfanout136 _2425_/Q VGND VGND VPWR VPWR _2185_/B sky130_fd_sc_hd__clkdlybuf4s50_1
X_1539_ locked _1539_/B VGND VGND VPWR VPWR wire72/A sky130_fd_sc_hd__nand2_1
Xfanout125 _2431_/Q VGND VGND VPWR VPWR _2230_/A sky130_fd_sc_hd__clkdlybuf4s50_1
X_2588_ clkload8/A _2588_/D load_slew168/X VGND VGND VPWR VPWR _2588_/Q sky130_fd_sc_hd__dfrtp_1
X_1608_ _1237_/Y _1607_/Y _1638_/S VGND VGND VPWR VPWR _2447_/D sky130_fd_sc_hd__mux2i_1
Xfanout114 _2331_/A VGND VGND VPWR VPWR _1484_/A sky130_fd_sc_hd__clkdlybuf4s50_1
Xfanout169 fanout171/X VGND VGND VPWR VPWR fanout169/X sky130_fd_sc_hd__clkdlybuf4s50_1
XPHY_EDGE_ROW_16_Right_16 VGND VGND VPWR VPWR sky130_fd_sc_hd__decap_3
X_1890_ _2529_/Q _2603_/Q _1902_/S VGND VGND VPWR VPWR _1890_/Y sky130_fd_sc_hd__mux2i_1
XFILLER_41_281 VGND VGND VPWR VPWR sky130_fd_sc_hd__decap_8
XPHY_EDGE_ROW_25_Right_25 VGND VGND VPWR VPWR sky130_fd_sc_hd__decap_3
X_2511_ _2606_/CLK _2511_/D _2429_/SET_B VGND VGND VPWR VPWR _2511_/Q sky130_fd_sc_hd__dfrtp_1
XFILLER_45_3 VGND VGND VPWR VPWR sky130_fd_sc_hd__decap_8
X_2442_ _2592_/CLK _2442_/D fanout157/A VGND VGND VPWR VPWR _2442_/Q sky130_fd_sc_hd__dfrtp_1
X_2373_ _2373_/A _2373_/B VGND VGND VPWR VPWR _2373_/Y sky130_fd_sc_hd__nand2_1
XPHY_EDGE_ROW_34_Right_34 VGND VGND VPWR VPWR sky130_fd_sc_hd__decap_3
X_1324_ _2272_/A _1486_/A VGND VGND VPWR VPWR _1339_/A sky130_fd_sc_hd__nand2_1
X_1255_ _2470_/Q VGND VGND VPWR VPWR _1255_/Y sky130_fd_sc_hd__inv_1
XPHY_EDGE_ROW_43_Right_43 VGND VGND VPWR VPWR sky130_fd_sc_hd__decap_3
XPHY_EDGE_ROW_52_Right_52 VGND VGND VPWR VPWR sky130_fd_sc_hd__decap_3
XFILLER_15_204 VGND VGND VPWR VPWR sky130_fd_sc_hd__fill_1
XFILLER_15_248 VGND VGND VPWR VPWR sky130_fd_sc_hd__fill_2
XPHY_EDGE_ROW_61_Right_61 VGND VGND VPWR VPWR sky130_fd_sc_hd__decap_3
XTAP_TAPCELL_ROW_25_276 VGND VPWR sky130_fd_sc_hd__tapvpwrvgnd_1
XPHY_EDGE_ROW_70_Right_70 VGND VGND VPWR VPWR sky130_fd_sc_hd__decap_3
XFILLER_2_163 VGND VGND VPWR VPWR sky130_fd_sc_hd__fill_2
XFILLER_2_141 VGND VGND VPWR VPWR sky130_fd_sc_hd__fill_1
XFILLER_0_33 VGND VGND VPWR VPWR sky130_fd_sc_hd__decap_12
XFILLER_0_55 VGND VGND VPWR VPWR sky130_fd_sc_hd__fill_1
X_1942_ _1942_/A _1942_/B VGND VGND VPWR VPWR _1942_/Y sky130_fd_sc_hd__nand2_1
X_1873_ _1873_/A _1945_/B VGND VGND VPWR VPWR _1873_/Y sky130_fd_sc_hd__nand2_1
X_2425_ _2616_/CLK _2425_/D fanout190/X VGND VGND VPWR VPWR _2425_/Q sky130_fd_sc_hd__dfstp_2
XFILLER_56_104 VGND VGND VPWR VPWR sky130_fd_sc_hd__fill_1
X_2356_ _2356_/A _2356_/B VGND VGND VPWR VPWR _2356_/Y sky130_fd_sc_hd__xnor2_1
XFILLER_64_192 VGND VGND VPWR VPWR sky130_fd_sc_hd__decap_4
X_1307_ _1292_/X _1296_/Y _1297_/Y _1306_/Y VGND VGND VPWR VPWR _1307_/Y sky130_fd_sc_hd__a31oi_1
X_1238_ _2446_/Q VGND VGND VPWR VPWR _1238_/Y sky130_fd_sc_hd__inv_1
XTAP_TAPCELL_ROW_39_346 VGND VPWR sky130_fd_sc_hd__tapvpwrvgnd_1
X_2287_ _2331_/A _2287_/B VGND VGND VPWR VPWR _2289_/B sky130_fd_sc_hd__xnor2_1
XTAP_TAPCELL_ROW_22_257 VGND VPWR sky130_fd_sc_hd__tapvpwrvgnd_1
XTAP_TAPCELL_ROW_13_213 VGND VPWR sky130_fd_sc_hd__tapvpwrvgnd_1
X_2210_ _2136_/B _2208_/Y _2209_/Y _2196_/Y VGND VGND VPWR VPWR _2426_/D sky130_fd_sc_hd__a31oi_1
Xload_slew147 fanout146/X VGND VGND VPWR VPWR load_slew147/X sky130_fd_sc_hd__clkbuf_4
Xload_slew158 fanout157/X VGND VGND VPWR VPWR _2437_/SET_B sky130_fd_sc_hd__buf_4
X_2141_ _2137_/A _2474_/Q _2140_/X VGND VGND VPWR VPWR _2141_/Y sky130_fd_sc_hd__a21oi_1
X_2072_ _2462_/Q _2404_/Q _2074_/S VGND VGND VPWR VPWR _2404_/D sky130_fd_sc_hd__mux2_1
XTAP_TAPCELL_ROW_36_327 VGND VPWR sky130_fd_sc_hd__tapvpwrvgnd_1
XTAP_TAPCELL_ROW_44_371 VGND VPWR sky130_fd_sc_hd__tapvpwrvgnd_1
X_1925_ _1924_/B _1923_/Y _1924_/Y VGND VGND VPWR VPWR _2541_/D sky130_fd_sc_hd__o21ai_0
X_1787_ _2466_/Q _2408_/Q VGND VGND VPWR VPWR _1789_/A sky130_fd_sc_hd__xnor2_1
X_1856_ _1930_/B _1854_/Y _1855_/Y VGND VGND VPWR VPWR _2518_/D sky130_fd_sc_hd__o21ai_0
Xfanout5 _2076_/S VGND VGND VPWR VPWR _2060_/S sky130_fd_sc_hd__clkdlybuf4s50_1
XFILLER_69_273 VGND VGND VPWR VPWR sky130_fd_sc_hd__decap_6
X_2408_ _2607_/CLK _2408_/D wire181/X VGND VGND VPWR VPWR _2408_/Q sky130_fd_sc_hd__dfrtp_1
XPHY_EDGE_ROW_2_Right_2 VGND VGND VPWR VPWR sky130_fd_sc_hd__decap_3
X_2339_ _2339_/A _2339_/B VGND VGND VPWR VPWR _2339_/X sky130_fd_sc_hd__xor2_1
XTAP_TAPCELL_ROW_67_485 VGND VPWR sky130_fd_sc_hd__tapvpwrvgnd_1
XFILLER_55_27 VGND VGND VPWR VPWR sky130_fd_sc_hd__decap_4
XFILLER_52_195 VGND VGND VPWR VPWR sky130_fd_sc_hd__fill_1
XFILLER_37_181 VGND VGND VPWR VPWR sky130_fd_sc_hd__decap_12
XFILLER_4_258 VGND VGND VPWR VPWR sky130_fd_sc_hd__fill_1
XFILLER_20_63 VGND VGND VPWR VPWR sky130_fd_sc_hd__fill_1
XTAP_TAPCELL_ROW_58_441 VGND VPWR sky130_fd_sc_hd__tapvpwrvgnd_1
XFILLER_29_61 VGND VGND VPWR VPWR sky130_fd_sc_hd__fill_1
XFILLER_43_195 VGND VGND VPWR VPWR sky130_fd_sc_hd__decap_6
XTAP_TAPCELL_ROW_41_352 VGND VPWR sky130_fd_sc_hd__tapvpwrvgnd_1
X_1572_ _1977_/B _1572_/B VGND VGND VPWR VPWR _2620_/D sky130_fd_sc_hd__nor2_1
X_1641_ _2383_/A _2465_/Q VGND VGND VPWR VPWR _1641_/Y sky130_fd_sc_hd__nand2_1
X_1710_ _2460_/Q _2402_/Q VGND VGND VPWR VPWR _1756_/A sky130_fd_sc_hd__nand2_1
X_2124_ _2448_/Q _2390_/Q _2124_/C VGND VGND VPWR VPWR _2125_/D sky130_fd_sc_hd__nor3_1
X_2055_ _2445_/Q hold366/X _2074_/S VGND VGND VPWR VPWR _2387_/D sky130_fd_sc_hd__mux2_1
XFILLER_26_107 VGND VGND VPWR VPWR sky130_fd_sc_hd__fill_2
X_1839_ _2512_/Q _2586_/Q _1956_/S VGND VGND VPWR VPWR _1839_/Y sky130_fd_sc_hd__mux2i_1
X_1908_ _2535_/Q _2561_/Q _1971_/S VGND VGND VPWR VPWR _1908_/Y sky130_fd_sc_hd__mux2i_1
XFILLER_57_243 VGND VGND VPWR VPWR sky130_fd_sc_hd__fill_1
XTAP_TAPCELL_ROW_55_422 VGND VPWR sky130_fd_sc_hd__tapvpwrvgnd_1
XFILLER_25_140 VGND VGND VPWR VPWR sky130_fd_sc_hd__decap_4
XFILLER_48_265 VGND VGND VPWR VPWR sky130_fd_sc_hd__decap_12
XFILLER_16_151 VGND VGND VPWR VPWR sky130_fd_sc_hd__decap_6
XFILLER_16_195 VGND VGND VPWR VPWR sky130_fd_sc_hd__fill_1
X_1555_ _2474_/Q _2473_/Q _2472_/Q _1555_/D VGND VGND VPWR VPWR wire60/A sky130_fd_sc_hd__nor4_1
X_1624_ _1229_/Y _1623_/Y _1624_/S VGND VGND VPWR VPWR _2455_/D sky130_fd_sc_hd__mux2i_1
XFILLER_54_235 VGND VGND VPWR VPWR sky130_fd_sc_hd__decap_8
XFILLER_39_276 VGND VGND VPWR VPWR sky130_fd_sc_hd__decap_4
XFILLER_39_254 VGND VGND VPWR VPWR sky130_fd_sc_hd__fill_1
X_1486_ _1486_/A _2242_/A _1523_/A _1486_/D VGND VGND VPWR VPWR _1486_/Y sky130_fd_sc_hd__nor4_1
X_2107_ _2105_/Y _2106_/Y _2110_/B1 VGND VGND VPWR VPWR _2416_/D sky130_fd_sc_hd__a21oi_1
XFILLER_54_279 VGND VGND VPWR VPWR sky130_fd_sc_hd__fill_1
X_2038_ _2038_/A _2038_/B VGND VGND VPWR VPWR _2038_/Y sky130_fd_sc_hd__nor2_1
XFILLER_22_110 VGND VGND VPWR VPWR sky130_fd_sc_hd__fill_2
Xhold350 _2560_/Q VGND VGND VPWR VPWR _1978_/A sky130_fd_sc_hd__dlygate4sd3_1
Xhold372 _2394_/Q VGND VGND VPWR VPWR hold372/X sky130_fd_sc_hd__dlygate4sd3_1
Xhold361 _2391_/Q VGND VGND VPWR VPWR hold361/X sky130_fd_sc_hd__dlygate4sd3_1
XFILLER_60_205 VGND VGND VPWR VPWR sky130_fd_sc_hd__decap_12
XFILLER_9_147 VGND VGND VPWR VPWR sky130_fd_sc_hd__decap_6
XFILLER_9_169 VGND VGND VPWR VPWR sky130_fd_sc_hd__fill_2
X_1340_ _1340_/A _1340_/B _1340_/C _1341_/B VGND VGND VPWR VPWR _1340_/Y sky130_fd_sc_hd__nand4_1
X_1271_ _2176_/A _2198_/B VGND VGND VPWR VPWR _1477_/A sky130_fd_sc_hd__nor2_1
XFILLER_3_55 VGND VGND VPWR VPWR sky130_fd_sc_hd__fill_1
XTAP_TAPCELL_ROW_8_191 VGND VPWR sky130_fd_sc_hd__tapvpwrvgnd_1
XFILLER_36_246 VGND VGND VPWR VPWR sky130_fd_sc_hd__fill_1
Xclkbuf_leaf_8_clk clkload0/A VGND VGND VPWR VPWR _2616_/CLK sky130_fd_sc_hd__clkbuf_16
X_1538_ i2s_bclk _1603_/A VGND VGND VPWR VPWR _2633_/D sky130_fd_sc_hd__and2_0
Xfanout137 _2425_/Q VGND VGND VPWR VPWR _1389_/B sky130_fd_sc_hd__clkdlybuf4s50_1
X_1469_ _1472_/A _1495_/B VGND VGND VPWR VPWR _1469_/Y sky130_fd_sc_hd__nand2_1
X_2587_ clkload8/A _2587_/D load_slew172/X VGND VGND VPWR VPWR _2587_/Q sky130_fd_sc_hd__dfrtp_1
Xfanout126 _2257_/B VGND VGND VPWR VPWR _2255_/A sky130_fd_sc_hd__clkdlybuf4s50_1
X_1607_ _2383_/A _2448_/Q VGND VGND VPWR VPWR _1607_/Y sky130_fd_sc_hd__nand2_1
Xfanout104 _2486_/Q VGND VGND VPWR VPWR _2332_/A sky130_fd_sc_hd__clkdlybuf4s50_1
Xfanout115 _2435_/Q VGND VGND VPWR VPWR _2331_/A sky130_fd_sc_hd__clkdlybuf4s50_1
Xfanout148 fanout192/X VGND VGND VPWR VPWR fanout148/X sky130_fd_sc_hd__clkdlybuf4s50_1
Xfanout159 fanout159/A VGND VGND VPWR VPWR fanout159/X sky130_fd_sc_hd__clkdlybuf4s50_1
XFILLER_27_202 VGND VGND VPWR VPWR sky130_fd_sc_hd__decap_3
XFILLER_27_279 VGND VGND VPWR VPWR sky130_fd_sc_hd__fill_1
XFILLER_5_3 VGND VGND VPWR VPWR sky130_fd_sc_hd__decap_6
XTAP_TAPCELL_ROW_5_172 VGND VPWR sky130_fd_sc_hd__tapvpwrvgnd_1
X_2510_ _2607_/CLK _2510_/D fanout187/A VGND VGND VPWR VPWR _2510_/Q sky130_fd_sc_hd__dfrtp_1
XFILLER_38_3 VGND VGND VPWR VPWR sky130_fd_sc_hd__fill_1
X_1323_ _1312_/Y _1317_/Y _1322_/Y VGND VGND VPWR VPWR _1323_/Y sky130_fd_sc_hd__o21ai_0
XFILLER_5_150 VGND VGND VPWR VPWR sky130_fd_sc_hd__fill_1
X_2441_ _2592_/CLK _2441_/D fanout148/X VGND VGND VPWR VPWR _2441_/Q sky130_fd_sc_hd__dfrtp_1
X_2372_ _2609_/Q _2368_/Y _2371_/X _2369_/Y _2440_/Q VGND VGND VPWR VPWR _2440_/D
+ sky130_fd_sc_hd__a32o_1
X_1254_ _2502_/Q VGND VGND VPWR VPWR _1254_/Y sky130_fd_sc_hd__inv_1
XFILLER_32_260 VGND VGND VPWR VPWR sky130_fd_sc_hd__fill_1
XFILLER_3_109 VGND VGND VPWR VPWR sky130_fd_sc_hd__decap_3
XFILLER_58_27 VGND VGND VPWR VPWR sky130_fd_sc_hd__fill_1
XFILLER_2_197 VGND VGND VPWR VPWR sky130_fd_sc_hd__decap_8
Xmax_cap4 _2101_/Y VGND VGND VPWR VPWR _2110_/B1 sky130_fd_sc_hd__buf_1
XFILLER_0_45 VGND VGND VPWR VPWR sky130_fd_sc_hd__decap_6
X_1941_ _2546_/Q _2572_/Q _1944_/S VGND VGND VPWR VPWR _1941_/Y sky130_fd_sc_hd__mux2i_1
X_1872_ _2523_/Q _2597_/Q _1917_/S VGND VGND VPWR VPWR _1872_/Y sky130_fd_sc_hd__mux2i_1
X_2424_ _2616_/CLK _2424_/D fanout190/X VGND VGND VPWR VPWR _2424_/Q sky130_fd_sc_hd__dfstp_2
X_1306_ _2476_/Q _1296_/B _1305_/Y _2477_/Q VGND VGND VPWR VPWR _1306_/Y sky130_fd_sc_hd__o22ai_1
X_2286_ _2287_/B _2480_/Q _2286_/S VGND VGND VPWR VPWR _2286_/Y sky130_fd_sc_hd__mux2i_1
X_2355_ _2356_/A _2356_/B VGND VGND VPWR VPWR _2355_/Y sky130_fd_sc_hd__nor2_1
XFILLER_44_29 VGND VGND VPWR VPWR sky130_fd_sc_hd__fill_1
X_1237_ _2447_/Q VGND VGND VPWR VPWR _1237_/Y sky130_fd_sc_hd__inv_1
XFILLER_20_241 VGND VGND VPWR VPWR sky130_fd_sc_hd__decap_6
XTAP_TAPCELL_ROW_22_258 VGND VPWR sky130_fd_sc_hd__tapvpwrvgnd_1
XPHY_EDGE_ROW_8_Left_79 VGND VGND VPWR VPWR sky130_fd_sc_hd__decap_3
XFILLER_55_160 VGND VGND VPWR VPWR sky130_fd_sc_hd__decap_4
XFILLER_18_85 VGND VGND VPWR VPWR sky130_fd_sc_hd__fill_2
XTAP_TAPCELL_ROW_13_214 VGND VPWR sky130_fd_sc_hd__tapvpwrvgnd_1
XFILLER_7_223 VGND VGND VPWR VPWR sky130_fd_sc_hd__fill_1
XFILLER_59_70 VGND VGND VPWR VPWR sky130_fd_sc_hd__fill_1
X_2140_ _2201_/B _2473_/Q _2140_/C VGND VGND VPWR VPWR _2140_/X sky130_fd_sc_hd__maj3_1
X_2071_ _2461_/Q hold371/X _2074_/S VGND VGND VPWR VPWR _2403_/D sky130_fd_sc_hd__mux2_1
XTAP_TAPCELL_ROW_36_328 VGND VPWR sky130_fd_sc_hd__tapvpwrvgnd_1
Xload_slew62 _1926_/S VGND VGND VPWR VPWR _1944_/S sky130_fd_sc_hd__buf_4
XFILLER_61_185 VGND VGND VPWR VPWR sky130_fd_sc_hd__decap_12
X_1855_ _1855_/A _1930_/B VGND VGND VPWR VPWR _1855_/Y sky130_fd_sc_hd__nand2_1
X_1924_ _1924_/A _1924_/B VGND VGND VPWR VPWR _1924_/Y sky130_fd_sc_hd__nand2_1
X_1786_ _2466_/Q _2408_/Q VGND VGND VPWR VPWR _1786_/Y sky130_fd_sc_hd__nand2_1
X_2407_ _2607_/CLK _2407_/D wire181/X VGND VGND VPWR VPWR _2407_/Q sky130_fd_sc_hd__dfrtp_1
XFILLER_55_17 VGND VGND VPWR VPWR sky130_fd_sc_hd__fill_2
X_2269_ _2136_/B _2267_/Y _2268_/Y _1466_/B _1512_/A VGND VGND VPWR VPWR _2430_/D
+ sky130_fd_sc_hd__a32oi_1
XFILLER_29_149 VGND VGND VPWR VPWR sky130_fd_sc_hd__decap_8
XFILLER_29_105 VGND VGND VPWR VPWR sky130_fd_sc_hd__decap_6
X_2338_ _2321_/A _2323_/B _2339_/A _2320_/Y VGND VGND VPWR VPWR _2349_/B sky130_fd_sc_hd__o211ai_1
XTAP_TAPCELL_ROW_67_486 VGND VPWR sky130_fd_sc_hd__tapvpwrvgnd_1
XFILLER_37_193 VGND VGND VPWR VPWR sky130_fd_sc_hd__decap_4
XTAP_TAPCELL_ROW_50_397 VGND VPWR sky130_fd_sc_hd__tapvpwrvgnd_1
XFILLER_45_61 VGND VGND VPWR VPWR sky130_fd_sc_hd__fill_1
XTAP_TAPCELL_ROW_41_353 VGND VPWR sky130_fd_sc_hd__tapvpwrvgnd_1
X_1571_ _2620_/Q _1573_/C VGND VGND VPWR VPWR _1572_/B sky130_fd_sc_hd__xnor2_1
X_1640_ _1244_/Y _1639_/Y _2384_/S VGND VGND VPWR VPWR _2463_/D sky130_fd_sc_hd__mux2i_1
XFILLER_3_281 VGND VGND VPWR VPWR sky130_fd_sc_hd__decap_8
XFILLER_3_270 VGND VGND VPWR VPWR sky130_fd_sc_hd__decap_8
X_2123_ _2443_/Q _2123_/B VGND VGND VPWR VPWR _2125_/C sky130_fd_sc_hd__nor2_1
XFILLER_20_3 VGND VGND VPWR VPWR sky130_fd_sc_hd__decap_4
XTAP_TAPCELL_ROW_64_467 VGND VPWR sky130_fd_sc_hd__tapvpwrvgnd_1
X_2054_ _2444_/Q hold365/X _2054_/S VGND VGND VPWR VPWR _2386_/D sky130_fd_sc_hd__mux2_1
X_1838_ _1909_/B _1836_/Y _1837_/Y VGND VGND VPWR VPWR _2512_/D sky130_fd_sc_hd__o21ai_0
X_1907_ _1909_/B _1905_/Y _1906_/Y VGND VGND VPWR VPWR _1907_/Y sky130_fd_sc_hd__o21ai_0
X_1769_ _1763_/A _1760_/Y _2119_/B VGND VGND VPWR VPWR _1770_/B sky130_fd_sc_hd__a21oi_1
XFILLER_57_233 VGND VGND VPWR VPWR sky130_fd_sc_hd__fill_2
XTAP_TAPCELL_ROW_55_423 VGND VPWR sky130_fd_sc_hd__tapvpwrvgnd_1
XFILLER_48_277 VGND VGND VPWR VPWR sky130_fd_sc_hd__decap_12
XFILLER_48_222 VGND VGND VPWR VPWR sky130_fd_sc_hd__decap_4
XFILLER_63_225 VGND VGND VPWR VPWR sky130_fd_sc_hd__decap_12
XFILLER_56_93 VGND VGND VPWR VPWR sky130_fd_sc_hd__fill_1
XFILLER_56_82 VGND VGND VPWR VPWR sky130_fd_sc_hd__fill_2
XFILLER_56_71 VGND VGND VPWR VPWR sky130_fd_sc_hd__fill_2
XFILLER_16_141 VGND VGND VPWR VPWR sky130_fd_sc_hd__fill_1
XFILLER_68_3 VGND VGND VPWR VPWR sky130_fd_sc_hd__fill_1
X_1554_ _1688_/A _2200_/A _2201_/C _1680_/A VGND VGND VPWR VPWR _1555_/D sky130_fd_sc_hd__nand4_1
X_1485_ _1485_/A _1485_/B _1523_/B VGND VGND VPWR VPWR _1490_/A sky130_fd_sc_hd__nand3_1
X_1623_ _1627_/A _2456_/Q VGND VGND VPWR VPWR _1623_/Y sky130_fd_sc_hd__nand2_1
.ends
