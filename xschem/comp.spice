** sch_path: /foss/designs/comp.sch
.subckt comp uo_out[6] ua[0] VDPWR uo_out[3] VGND
*.PININFO ua[0]:I uo_out[6]:O uo_out[3]:I VGND:I VDPWR:I
XM3 net5 net3 net1 VGND sky130_fd_pr__nfet_01v8 L=1 W=4 nf=4
XR10 net2 VDPWR VGND sky130_fd_pr__res_xhigh_po_0p35 L=40 mult=1
XM2 net6 ua[0] net1 VGND sky130_fd_pr__nfet_01v8 L=1 W=4 nf=2
XR1 net3 VDPWR VGND sky130_fd_pr__res_xhigh_po_0p35 L=20 mult=1
XR2 VGND net3 VGND sky130_fd_pr__res_xhigh_po_0p35 L=20 mult=1
XM5 net6 net5 VDPWR VDPWR sky130_fd_pr__pfet_01v8 L=1 W=12 nf=4
XM4 net2 net2 VGND VGND sky130_fd_pr__nfet_01v8 L=1 W=2 nf=1
XM1 net1 net2 VGND VGND sky130_fd_pr__nfet_01v8 L=1 W=2 nf=1
XM17 ua[0] net4 VGND VGND sky130_fd_pr__nfet_01v8 L=0.15 W=20 nf=8
XM18 net4 uo_out[3] VDPWR VDPWR sky130_fd_pr__pfet_01v8 L=0.15 W=2 nf=1
XM19 net4 uo_out[3] VGND VGND sky130_fd_pr__nfet_01v8 L=0.15 W=1 nf=1
XM6 net5 net5 VDPWR VDPWR sky130_fd_pr__pfet_01v8 L=1 W=4 nf=2
XM7 net5 net6 VDPWR VDPWR sky130_fd_pr__pfet_01v8 L=1 W=12 nf=4
XM8 net6 net6 VDPWR VDPWR sky130_fd_pr__pfet_01v8 L=1 W=4 nf=2
XM9 net7 net7 VDPWR VDPWR sky130_fd_pr__pfet_01v8 L=1 W=8 nf=4
XM10 net7 net6 VGND VGND sky130_fd_pr__nfet_01v8 L=1 W=4 nf=2
XM11 net8 net7 VDPWR VDPWR sky130_fd_pr__pfet_01v8 L=0.15 W=8 nf=4
XM12 net8 net5 VGND VGND sky130_fd_pr__nfet_01v8 L=0.2 W=4 nf=2
XM13 uo_out[6] net8 VDPWR VDPWR sky130_fd_pr__pfet_01v8 L=0.15 W=8 nf=4
XM14 uo_out[6] net8 VGND VGND sky130_fd_pr__nfet_01v8 L=0.2 W=4 nf=2
.ends
