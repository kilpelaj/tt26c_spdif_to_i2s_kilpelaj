* NGSPICE file created from tt_um_spdif_to_i2s_kilpelaj.ext - technology: sky130A

.subckt sky130_fd_pr__nfet_01v8_GT9DNQ B D0 G S1 a_229_n231#
X0 S1 G D0 B sky130_fd_pr__nfet_01v8 ad=0.29 pd=2.29 as=0.58 ps=4.58 w=2 l=1
X1 a_229_n231# G S1 B sky130_fd_pr__nfet_01v8 ad=0.58 pd=4.58 as=0.29 ps=2.29 w=2 l=1
.ends

.subckt sky130_fd_pr__pfet_01v8_99L4LZ B D0 G S1 D2 S3 a_159_n164#
X0 a_159_n164# G S3 B sky130_fd_pr__pfet_01v8 ad=0.62 pd=4.62 as=0.33 ps=2.33 w=2 l=0.15
X1 S3 G D2 B sky130_fd_pr__pfet_01v8 ad=0.33 pd=2.33 as=0.33 ps=2.33 w=2 l=0.15
X2 S1 G D0 B sky130_fd_pr__pfet_01v8 ad=0.33 pd=2.33 as=0.62 ps=4.62 w=2 l=0.15
X3 D2 G S1 B sky130_fd_pr__pfet_01v8 ad=0.33 pd=2.33 as=0.33 ps=2.33 w=2 l=0.15
.ends

.subckt sky130_fd_pr__nfet_01v8_U5JGNU B D0 G S1 a_69_n231#
X0 S1 G D0 B sky130_fd_pr__nfet_01v8 ad=0.29 pd=2.29 as=0.58 ps=4.58 w=2 l=0.2
X1 a_69_n231# G S1 B sky130_fd_pr__nfet_01v8 ad=0.58 pd=4.58 as=0.29 ps=2.29 w=2 l=0.2
.ends

.subckt sky130_fd_pr__nfet_01v8_8UCVU5 B D S G
X0 S G D B sky130_fd_pr__nfet_01v8 ad=0.58 pd=4.58 as=0.58 ps=4.58 w=2 l=1
.ends

.subckt sky130_fd_pr__nfet_01v8_ST42GL B D0 G S1 D2 S3 D4 S5 D6 S7 D8 S9 a_447_n231#
X0 S7 G D6 B sky130_fd_pr__nfet_01v8 ad=0.33 pd=2.33 as=0.33 ps=2.33 w=2 l=0.15
X1 S3 G D2 B sky130_fd_pr__nfet_01v8 ad=0.33 pd=2.33 as=0.33 ps=2.33 w=2 l=0.15
X2 a_447_n231# G S9 B sky130_fd_pr__nfet_01v8 ad=0.62 pd=4.62 as=0.33 ps=2.33 w=2 l=0.15
X3 D6 G S5 B sky130_fd_pr__nfet_01v8 ad=0.33 pd=2.33 as=0.33 ps=2.33 w=2 l=0.15
X4 D4 G S3 B sky130_fd_pr__nfet_01v8 ad=0.33 pd=2.33 as=0.33 ps=2.33 w=2 l=0.15
X5 S1 G D0 B sky130_fd_pr__nfet_01v8 ad=0.33 pd=2.33 as=0.62 ps=4.62 w=2 l=0.15
X6 S5 G D4 B sky130_fd_pr__nfet_01v8 ad=0.33 pd=2.33 as=0.33 ps=2.33 w=2 l=0.15
X7 S9 G D8 B sky130_fd_pr__nfet_01v8 ad=0.33 pd=2.33 as=0.33 ps=2.33 w=2 l=0.15
X8 D8 G S7 B sky130_fd_pr__nfet_01v8 ad=0.33 pd=2.33 as=0.33 ps=2.33 w=2 l=0.15
X9 D2 G S1 B sky130_fd_pr__nfet_01v8 ad=0.33 pd=2.33 as=0.33 ps=2.33 w=2 l=0.15
.ends

.subckt sky130_fd_pr__pfet_01v8_TPLPJ6 B D S G
X0 S G D B sky130_fd_pr__pfet_01v8 ad=0.58 pd=4.58 as=0.58 ps=4.58 w=2 l=0.15
.ends

.subckt sky130_fd_pr__res_xhigh_po_0p69_3D2XQL B R1_0 R2_0 R1_1 R2_1 R1_2 R2_2 R1_3
+ R2_3
X0 R1_3 R2_3 B sky130_fd_pr__res_xhigh_po_0p69 l=80
X1 R1_1 R2_1 B sky130_fd_pr__res_xhigh_po_0p69 l=80
X2 R1_0 R2_0 B sky130_fd_pr__res_xhigh_po_0p69 l=80
X3 R1_2 R2_2 B sky130_fd_pr__res_xhigh_po_0p69 l=80
.ends

.subckt sky130_fd_pr__pfet_01v8_U6MDYH B D0 G S1 D2 S3 D4 S5 a_745_n164#
X0 S3 G D2 B sky130_fd_pr__pfet_01v8 ad=0.29 pd=2.29 as=0.29 ps=2.29 w=2 l=1
X1 D4 G S3 B sky130_fd_pr__pfet_01v8 ad=0.29 pd=2.29 as=0.29 ps=2.29 w=2 l=1
X2 S1 G D0 B sky130_fd_pr__pfet_01v8 ad=0.29 pd=2.29 as=0.58 ps=4.58 w=2 l=1
X3 D2 G S1 B sky130_fd_pr__pfet_01v8 ad=0.29 pd=2.29 as=0.29 ps=2.29 w=2 l=1
X4 a_745_n164# G S5 B sky130_fd_pr__pfet_01v8 ad=0.58 pd=4.58 as=0.29 ps=2.29 w=2 l=1
X5 S5 G D4 B sky130_fd_pr__pfet_01v8 ad=0.29 pd=2.29 as=0.29 ps=2.29 w=2 l=1
.ends

.subckt sky130_fd_pr__nfet_01v8_DSPFQQ B D S G
X0 S G D B sky130_fd_pr__nfet_01v8 ad=0.29 pd=2.58 as=0.29 ps=2.58 w=1 l=0.15
.ends

.subckt sky130_fd_pr__pfet_01v8_S8FMYS B D0 G S1 a_229_n164#
X0 S1 G D0 B sky130_fd_pr__pfet_01v8 ad=0.29 pd=2.29 as=0.58 ps=4.58 w=2 l=1
X1 a_229_n164# G S1 B sky130_fd_pr__pfet_01v8 ad=0.58 pd=4.58 as=0.29 ps=2.29 w=2 l=1
.ends

.subckt sky130_fd_pr__pfet_01v8_E4RPCE B D0 G S1 D2 S3 D4 S5 a_745_n164#
X0 S3 G D2 B sky130_fd_pr__pfet_01v8 ad=0.29 pd=2.29 as=0.29 ps=2.29 w=2 l=1
X1 D4 G S3 B sky130_fd_pr__pfet_01v8 ad=0.29 pd=2.29 as=0.29 ps=2.29 w=2 l=1
X2 S1 G D0 B sky130_fd_pr__pfet_01v8 ad=0.29 pd=2.29 as=0.58 ps=4.58 w=2 l=1
X3 D2 G S1 B sky130_fd_pr__pfet_01v8 ad=0.29 pd=2.29 as=0.29 ps=2.29 w=2 l=1
X4 a_745_n164# G S5 B sky130_fd_pr__pfet_01v8 ad=0.58 pd=4.58 as=0.29 ps=2.29 w=2 l=1
X5 S5 G D4 B sky130_fd_pr__pfet_01v8 ad=0.29 pd=2.29 as=0.29 ps=2.29 w=2 l=1
.ends

.subckt sky130_fd_pr__pfet_01v8_QR4GC9 B D0 G S1 D2 S3 a_487_n164#
X0 D2 G S1 B sky130_fd_pr__pfet_01v8 ad=0.29 pd=2.29 as=0.29 ps=2.29 w=2 l=1
X1 S3 G D2 B sky130_fd_pr__pfet_01v8 ad=0.29 pd=2.29 as=0.29 ps=2.29 w=2 l=1
X2 S1 G D0 B sky130_fd_pr__pfet_01v8 ad=0.29 pd=2.29 as=0.58 ps=4.58 w=2 l=1
X3 a_487_n164# G S3 B sky130_fd_pr__pfet_01v8 ad=0.58 pd=4.58 as=0.29 ps=2.29 w=2 l=1
.ends

.subckt sky130_fd_sc_hd__a21oi_1 VPWR VGND VPB VNB A2 A1 B1 Y
X0 a_199_47# A1 Y VNB sky130_fd_pr__nfet_01v8 ad=0.09588 pd=0.945 as=0.091 ps=0.93 w=0.65 l=0.15
X1 a_113_297# A2 VPWR VPB sky130_fd_pr__pfet_01v8_hvt ad=0.265 pd=2.53 as=0.1475 ps=1.295 w=1 l=0.15
X2 Y B1 VGND VNB sky130_fd_pr__nfet_01v8 ad=0.091 pd=0.93 as=0.17225 ps=1.83 w=0.65 l=0.15
X3 VPWR A1 a_113_297# VPB sky130_fd_pr__pfet_01v8_hvt ad=0.1475 pd=1.295 as=0.14 ps=1.28 w=1 l=0.15
X4 a_113_297# B1 Y VPB sky130_fd_pr__pfet_01v8_hvt ad=0.14 pd=1.28 as=0.265 ps=2.53 w=1 l=0.15
X5 VGND A2 a_199_47# VNB sky130_fd_pr__nfet_01v8 ad=0.17225 pd=1.83 as=0.09588 ps=0.945 w=0.65 l=0.15
.ends

.subckt sky130_fd_sc_hd__o41ai_1 VNB VPB VGND VPWR A1 A2 A3 A4 Y B1
X0 a_348_297# A3 a_193_297# VPB sky130_fd_pr__pfet_01v8_hvt ad=0.135 pd=1.27 as=0.3125 ps=1.625 w=1 l=0.15
X1 a_109_47# A1 VGND VNB sky130_fd_pr__nfet_01v8 ad=0.182 pd=1.86 as=0.11375 ps=1 w=0.65 l=0.15
X2 a_193_297# A4 Y VPB sky130_fd_pr__pfet_01v8_hvt ad=0.3125 pd=1.625 as=0.135 ps=1.27 w=1 l=0.15
X3 VPWR A1 a_432_297# VPB sky130_fd_pr__pfet_01v8_hvt ad=0.28 pd=2.56 as=0.175 ps=1.35 w=1 l=0.15
X4 VGND A4 a_109_47# VNB sky130_fd_pr__nfet_01v8 ad=0.08775 pd=0.92 as=0.20312 ps=1.275 w=0.65 l=0.15
X5 VGND A2 a_109_47# VNB sky130_fd_pr__nfet_01v8 ad=0.11375 pd=1 as=0.08775 ps=0.92 w=0.65 l=0.15
X6 a_109_47# A3 VGND VNB sky130_fd_pr__nfet_01v8 ad=0.08775 pd=0.92 as=0.08775 ps=0.92 w=0.65 l=0.15
X7 a_432_297# A2 a_348_297# VPB sky130_fd_pr__pfet_01v8_hvt ad=0.175 pd=1.35 as=0.135 ps=1.27 w=1 l=0.15
X8 Y B1 VPWR VPB sky130_fd_pr__pfet_01v8_hvt ad=0.135 pd=1.27 as=0.26 ps=2.52 w=1 l=0.15
X9 a_109_47# B1 Y VNB sky130_fd_pr__nfet_01v8 ad=0.20312 pd=1.275 as=0.169 ps=1.82 w=0.65 l=0.15
.ends

.subckt sky130_fd_sc_hd__dlygate4sd3_1 X A VPB VNB VGND VPWR
X0 VPWR A a_49_47# VPB sky130_fd_pr__pfet_01v8_hvt ad=0.0567 pd=0.69 as=0.1092 ps=1.36 w=0.42 l=0.15
X1 VGND a_285_47# a_391_47# VNB sky130_fd_pr__nfet_01v8 ad=0.097 pd=0.975 as=0.1092 ps=1.36 w=0.42 l=0.5
X2 X a_391_47# VPWR VPB sky130_fd_pr__pfet_01v8_hvt ad=0.26 pd=2.52 as=0.14075 ps=1.325 w=1 l=0.15
X3 VGND A a_49_47# VNB sky130_fd_pr__nfet_01v8 ad=0.0567 pd=0.69 as=0.1092 ps=1.36 w=0.42 l=0.15
X4 VPWR a_285_47# a_391_47# VPB sky130_fd_pr__pfet_01v8_hvt ad=0.14075 pd=1.325 as=0.1092 ps=1.36 w=0.42 l=0.5
X5 a_285_47# a_49_47# VGND VNB sky130_fd_pr__nfet_01v8 ad=0.1092 pd=1.36 as=0.0567 ps=0.69 w=0.42 l=0.5
X6 a_285_47# a_49_47# VPWR VPB sky130_fd_pr__pfet_01v8_hvt ad=0.1092 pd=1.36 as=0.0567 ps=0.69 w=0.42 l=0.5
X7 X a_391_47# VGND VNB sky130_fd_pr__nfet_01v8 ad=0.169 pd=1.82 as=0.097 ps=0.975 w=0.65 l=0.15
.ends

.subckt sky130_fd_sc_hd__decap_12 VGND VPWR VPB VNB
X0 VPWR VGND VPWR VPB sky130_fd_pr__pfet_01v8_hvt ad=0.2262 pd=2.26 as=0.4524 ps=4.52 w=0.87 l=4.73
X1 VGND VPWR VGND VNB sky130_fd_pr__nfet_01v8 ad=0.143 pd=1.62 as=0.286 ps=3.24 w=0.55 l=4.73
.ends

.subckt sky130_fd_sc_hd__decap_3 VPWR VGND VPB VNB
X0 VPWR VGND VPWR VPB sky130_fd_pr__pfet_01v8_hvt ad=0.2262 pd=2.26 as=0.4524 ps=4.52 w=0.87 l=0.59
X1 VGND VPWR VGND VNB sky130_fd_pr__nfet_01v8 ad=0.143 pd=1.62 as=0.286 ps=3.24 w=0.55 l=0.59
.ends

.subckt sky130_fd_sc_hd__o21ai_0 VNB VPB VGND VPWR B1 A1 Y A2
X0 a_120_369# A1 VPWR VPB sky130_fd_pr__pfet_01v8_hvt ad=0.0768 pd=0.88 as=0.1696 ps=1.81 w=0.64 l=0.15
X1 VGND A1 a_32_47# VNB sky130_fd_pr__nfet_01v8 ad=0.0588 pd=0.7 as=0.1113 ps=1.37 w=0.42 l=0.15
X2 Y A2 a_120_369# VPB sky130_fd_pr__pfet_01v8_hvt ad=0.0896 pd=0.92 as=0.0768 ps=0.88 w=0.64 l=0.15
X3 a_32_47# A2 VGND VNB sky130_fd_pr__nfet_01v8 ad=0.0588 pd=0.7 as=0.0588 ps=0.7 w=0.42 l=0.15
X4 VPWR B1 Y VPB sky130_fd_pr__pfet_01v8_hvt ad=0.1824 pd=1.85 as=0.0896 ps=0.92 w=0.64 l=0.15
X5 Y B1 a_32_47# VNB sky130_fd_pr__nfet_01v8 ad=0.1113 pd=1.37 as=0.0588 ps=0.7 w=0.42 l=0.15
.ends

.subckt sky130_fd_sc_hd__clkdlybuf4s25_1 VNB VPB VPWR VGND A X
X0 a_244_47# a_27_47# VPWR VPB sky130_fd_pr__pfet_01v8_hvt ad=0.2173 pd=2.17 as=0.19265 ps=1.415 w=0.82 l=0.25
X1 VPWR a_244_47# a_355_47# VPB sky130_fd_pr__pfet_01v8_hvt ad=0.2726 pd=1.61 as=0.2173 ps=2.17 w=0.82 l=0.25
X2 X a_355_47# VPWR VPB sky130_fd_pr__pfet_01v8_hvt ad=0.495 pd=2.99 as=0.2726 ps=1.61 w=1 l=0.15
X3 VPWR A a_27_47# VPB sky130_fd_pr__pfet_01v8_hvt ad=0.19265 pd=1.415 as=0.27 ps=2.54 w=1 l=0.15
X4 VGND A a_27_47# VNB sky130_fd_pr__nfet_01v8 ad=0.1228 pd=1.065 as=0.1134 ps=1.38 w=0.42 l=0.15
X5 VGND a_244_47# a_355_47# VNB sky130_fd_pr__nfet_01v8 ad=0.1856 pd=1.26 as=0.17225 ps=1.83 w=0.65 l=0.25
X6 X a_355_47# VGND VNB sky130_fd_pr__nfet_01v8 ad=0.2079 pd=1.83 as=0.1856 ps=1.26 w=0.42 l=0.15
X7 a_244_47# a_27_47# VGND VNB sky130_fd_pr__nfet_01v8 ad=0.17225 pd=1.83 as=0.1228 ps=1.065 w=0.65 l=0.25
.ends

.subckt sky130_fd_sc_hd__decap_6 VPWR VGND VPB VNB
X0 VPWR VGND VPWR VPB sky130_fd_pr__pfet_01v8_hvt ad=0.2262 pd=2.26 as=0.4524 ps=4.52 w=0.87 l=1.97
X1 VGND VPWR VGND VNB sky130_fd_pr__nfet_01v8 ad=0.143 pd=1.62 as=0.286 ps=3.24 w=0.55 l=1.97
.ends

.subckt sky130_fd_sc_hd__o211a_1 VNB VPB VGND VPWR X A1 A2 B1 C1
X0 VGND A1 a_215_47# VNB sky130_fd_pr__nfet_01v8 ad=0.10563 pd=0.975 as=0.169 ps=1.82 w=0.65 l=0.15
X1 a_510_47# B1 a_215_47# VNB sky130_fd_pr__nfet_01v8 ad=0.11375 pd=1 as=0.143 ps=1.09 w=0.65 l=0.15
X2 a_79_21# C1 VPWR VPB sky130_fd_pr__pfet_01v8_hvt ad=0.3 pd=2.6 as=0.175 ps=1.35 w=1 l=0.15
X3 VPWR B1 a_79_21# VPB sky130_fd_pr__pfet_01v8_hvt ad=0.175 pd=1.35 as=0.22 ps=1.44 w=1 l=0.15
X4 a_79_21# A2 a_297_297# VPB sky130_fd_pr__pfet_01v8_hvt ad=0.22 pd=1.44 as=0.1625 ps=1.325 w=1 l=0.15
X5 a_297_297# A1 VPWR VPB sky130_fd_pr__pfet_01v8_hvt ad=0.1625 pd=1.325 as=0.26 ps=2.52 w=1 l=0.15
X6 a_79_21# C1 a_510_47# VNB sky130_fd_pr__nfet_01v8 ad=0.195 pd=1.9 as=0.11375 ps=1 w=0.65 l=0.15
X7 VPWR a_79_21# X VPB sky130_fd_pr__pfet_01v8_hvt ad=0.26 pd=2.52 as=0.26 ps=2.52 w=1 l=0.15
X8 VGND a_79_21# X VNB sky130_fd_pr__nfet_01v8 ad=0.169 pd=1.82 as=0.169 ps=1.82 w=0.65 l=0.15
X9 a_215_47# A2 VGND VNB sky130_fd_pr__nfet_01v8 ad=0.143 pd=1.09 as=0.10563 ps=0.975 w=0.65 l=0.15
.ends

.subckt sky130_fd_sc_hd__clkdlybuf4s50_1 VNB VPB VGND VPWR A X
X0 a_283_47# a_27_47# VPWR VPB sky130_fd_pr__pfet_01v8_hvt ad=0.2173 pd=2.17 as=0.1701 ps=1.36 w=0.82 l=0.5
X1 VPWR A a_27_47# VPB sky130_fd_pr__pfet_01v8_hvt ad=0.1701 pd=1.36 as=0.27 ps=2.54 w=1 l=0.15
X2 VPWR a_283_47# a_390_47# VPB sky130_fd_pr__pfet_01v8_hvt ad=0.15575 pd=1.325 as=0.2173 ps=2.17 w=0.82 l=0.5
X3 VGND a_283_47# a_390_47# VNB sky130_fd_pr__nfet_01v8 ad=0.097 pd=0.975 as=0.17225 ps=1.83 w=0.65 l=0.5
X4 X a_390_47# VPWR VPB sky130_fd_pr__pfet_01v8_hvt ad=0.355 pd=2.71 as=0.15575 ps=1.325 w=1 l=0.15
X5 VGND A a_27_47# VNB sky130_fd_pr__nfet_01v8 ad=0.10435 pd=1.01 as=0.1134 ps=1.38 w=0.42 l=0.15
X6 a_283_47# a_27_47# VGND VNB sky130_fd_pr__nfet_01v8 ad=0.169 pd=1.82 as=0.10435 ps=1.01 w=0.65 l=0.5
X7 X a_390_47# VGND VNB sky130_fd_pr__nfet_01v8 ad=0.1491 pd=1.55 as=0.097 ps=0.975 w=0.42 l=0.15
.ends

.subckt sky130_fd_sc_hd__dfrtp_1 VGND VPWR VPB VNB CLK D RESET_B Q
X0 a_805_47# a_761_289# a_639_47# VNB sky130_fd_pr__nfet_01v8 ad=0.0441 pd=0.63 as=0.1401 ps=1.1 w=0.42 l=0.15
X1 a_1217_47# a_27_47# a_1108_47# VNB sky130_fd_pr__special_nfet_01v8 ad=0.0669 pd=0.75 as=0.0711 ps=0.755 w=0.36 l=0.15
X2 a_1283_21# a_1108_47# a_1462_47# VNB sky130_fd_pr__nfet_01v8 ad=0.1092 pd=1.36 as=0.06405 ps=0.725 w=0.42 l=0.15
X3 a_651_413# a_27_47# a_543_47# VPB sky130_fd_pr__pfet_01v8_hvt ad=0.1155 pd=0.97 as=0.07245 ps=0.765 w=0.42 l=0.15
X4 a_1108_47# a_193_47# a_761_289# VNB sky130_fd_pr__special_nfet_01v8 ad=0.0711 pd=0.755 as=0.0999 ps=0.985 w=0.36 l=0.15
X5 VGND RESET_B a_805_47# VNB sky130_fd_pr__nfet_01v8 ad=0.1346 pd=1.15 as=0.0441 ps=0.63 w=0.42 l=0.15
X6 Q a_1283_21# VPWR VPB sky130_fd_pr__pfet_01v8_hvt ad=0.26 pd=2.52 as=0.3012 ps=2.66 w=1 l=0.15
X7 VPWR CLK a_27_47# VPB sky130_fd_pr__pfet_01v8_hvt ad=0.0864 pd=0.91 as=0.1664 ps=1.8 w=0.64 l=0.15
X8 a_448_47# D VPWR VPB sky130_fd_pr__pfet_01v8_hvt ad=0.0651 pd=0.73 as=0.1092 ps=1.36 w=0.42 l=0.15
X9 a_761_289# a_543_47# VGND VNB sky130_fd_pr__nfet_01v8 ad=0.0999 pd=0.985 as=0.1346 ps=1.15 w=0.64 l=0.15
X10 a_193_47# a_27_47# VGND VNB sky130_fd_pr__nfet_01v8 ad=0.1092 pd=1.36 as=0.0567 ps=0.69 w=0.42 l=0.15
X11 a_1108_47# a_27_47# a_761_289# VPB sky130_fd_pr__pfet_01v8_hvt ad=0.0588 pd=0.7 as=0.12915 ps=1.185 w=0.42 l=0.15
X12 a_1462_47# RESET_B VGND VNB sky130_fd_pr__nfet_01v8 ad=0.06405 pd=0.725 as=0.12495 ps=1.015 w=0.42 l=0.15
X13 a_543_47# a_27_47# a_448_47# VNB sky130_fd_pr__special_nfet_01v8 ad=0.0594 pd=0.69 as=0.066 ps=0.745 w=0.36 l=0.15
X14 a_543_47# a_193_47# a_448_47# VPB sky130_fd_pr__pfet_01v8_hvt ad=0.07245 pd=0.765 as=0.0651 ps=0.73 w=0.42 l=0.15
X15 a_448_47# D VGND VNB sky130_fd_pr__nfet_01v8 ad=0.066 pd=0.745 as=0.2205 ps=1.89 w=0.42 l=0.15
X16 VPWR a_1283_21# a_1270_413# VPB sky130_fd_pr__pfet_01v8_hvt ad=0.0819 pd=0.81 as=0.0567 ps=0.69 w=0.42 l=0.15
X17 VPWR a_1108_47# a_1283_21# VPB sky130_fd_pr__pfet_01v8_hvt ad=0.1134 pd=1.38 as=0.0567 ps=0.69 w=0.42 l=0.15
X18 a_1270_413# a_193_47# a_1108_47# VPB sky130_fd_pr__pfet_01v8_hvt ad=0.0567 pd=0.69 as=0.0588 ps=0.7 w=0.42 l=0.15
X19 a_193_47# a_27_47# VPWR VPB sky130_fd_pr__pfet_01v8_hvt ad=0.1664 pd=1.8 as=0.0864 ps=0.91 w=0.64 l=0.15
X20 a_1283_21# RESET_B VPWR VPB sky130_fd_pr__pfet_01v8_hvt ad=0.0567 pd=0.69 as=0.0819 ps=0.81 w=0.42 l=0.15
X21 VPWR a_761_289# a_651_413# VPB sky130_fd_pr__pfet_01v8_hvt ad=0.07035 pd=0.755 as=0.1155 ps=0.97 w=0.42 l=0.15
X22 Q a_1283_21# VGND VNB sky130_fd_pr__nfet_01v8 ad=0.169 pd=1.82 as=0.2087 ps=2.02 w=0.65 l=0.15
X23 a_639_47# a_193_47# a_543_47# VNB sky130_fd_pr__special_nfet_01v8 ad=0.1401 pd=1.1 as=0.0594 ps=0.69 w=0.36 l=0.15
X24 VGND a_1283_21# a_1217_47# VNB sky130_fd_pr__nfet_01v8 ad=0.12495 pd=1.015 as=0.0669 ps=0.75 w=0.42 l=0.15
X25 a_651_413# RESET_B VPWR VPB sky130_fd_pr__pfet_01v8_hvt ad=0.1092 pd=1.36 as=0.07035 ps=0.755 w=0.42 l=0.15
X26 VGND CLK a_27_47# VNB sky130_fd_pr__nfet_01v8 ad=0.0567 pd=0.69 as=0.1092 ps=1.36 w=0.42 l=0.15
X27 a_761_289# a_543_47# VPWR VPB sky130_fd_pr__pfet_01v8_hvt ad=0.12915 pd=1.185 as=0.2184 ps=2.2 w=0.84 l=0.15
.ends

.subckt sky130_fd_sc_hd__maj3_1 VPB VNB VGND VPWR X C A B
X0 X a_27_47# VGND VNB sky130_fd_pr__nfet_01v8 ad=0.23725 pd=2.03 as=0.1474 ps=1.215 w=0.65 l=0.15
X1 X a_27_47# VPWR VPB sky130_fd_pr__pfet_01v8_hvt ad=0.365 pd=2.73 as=0.2492 ps=1.565 w=1 l=0.15
X2 a_109_341# C a_27_47# VPB sky130_fd_pr__pfet_01v8_hvt ad=0.0441 pd=0.63 as=0.1092 ps=1.36 w=0.42 l=0.15
X3 a_27_47# B a_265_341# VPB sky130_fd_pr__pfet_01v8_hvt ad=0.0567 pd=0.69 as=0.0441 ps=0.63 w=0.42 l=0.15
X4 VGND A a_109_47# VNB sky130_fd_pr__nfet_01v8 ad=0.0567 pd=0.69 as=0.0441 ps=0.63 w=0.42 l=0.15
X5 a_265_341# A VPWR VPB sky130_fd_pr__pfet_01v8_hvt ad=0.0441 pd=0.63 as=0.0567 ps=0.69 w=0.42 l=0.15
X6 VPWR A a_109_341# VPB sky130_fd_pr__pfet_01v8_hvt ad=0.0567 pd=0.69 as=0.0441 ps=0.63 w=0.42 l=0.15
X7 a_421_47# B a_27_47# VNB sky130_fd_pr__nfet_01v8 ad=0.0441 pd=0.63 as=0.0567 ps=0.69 w=0.42 l=0.15
X8 a_265_47# A VGND VNB sky130_fd_pr__nfet_01v8 ad=0.0441 pd=0.63 as=0.0567 ps=0.69 w=0.42 l=0.15
X9 VGND C a_421_47# VNB sky130_fd_pr__nfet_01v8 ad=0.1474 pd=1.215 as=0.0441 ps=0.63 w=0.42 l=0.15
X10 a_27_47# B a_265_47# VNB sky130_fd_pr__nfet_01v8 ad=0.0567 pd=0.69 as=0.0441 ps=0.63 w=0.42 l=0.15
X11 VPWR C a_421_341# VPB sky130_fd_pr__pfet_01v8_hvt ad=0.2492 pd=1.565 as=0.0441 ps=0.63 w=0.42 l=0.15
X12 a_421_341# B a_27_47# VPB sky130_fd_pr__pfet_01v8_hvt ad=0.0441 pd=0.63 as=0.0567 ps=0.69 w=0.42 l=0.15
X13 a_109_47# C a_27_47# VNB sky130_fd_pr__nfet_01v8 ad=0.0441 pd=0.63 as=0.1092 ps=1.36 w=0.42 l=0.15
.ends

.subckt sky130_fd_sc_hd__o22a_1 VPB VNB VGND VPWR B2 A2 A1 B1 X
X0 a_78_199# B1 a_215_47# VNB sky130_fd_pr__nfet_01v8 ad=0.08775 pd=0.92 as=0.169 ps=1.82 w=0.65 l=0.15
X1 VPWR A1 a_493_297# VPB sky130_fd_pr__pfet_01v8_hvt ad=0.26 pd=2.52 as=0.105 ps=1.21 w=1 l=0.15
X2 a_493_297# A2 a_78_199# VPB sky130_fd_pr__pfet_01v8_hvt ad=0.105 pd=1.21 as=0.235 ps=1.47 w=1 l=0.15
X3 VPWR a_78_199# X VPB sky130_fd_pr__pfet_01v8_hvt ad=0.3725 pd=1.745 as=0.28 ps=2.56 w=1 l=0.15
X4 VGND A2 a_215_47# VNB sky130_fd_pr__nfet_01v8 ad=0.08775 pd=0.92 as=0.11375 ps=1 w=0.65 l=0.15
X5 a_78_199# B2 a_292_297# VPB sky130_fd_pr__pfet_01v8_hvt ad=0.235 pd=1.47 as=0.1175 ps=1.235 w=1 l=0.15
X6 a_215_47# A1 VGND VNB sky130_fd_pr__nfet_01v8 ad=0.169 pd=1.82 as=0.08775 ps=0.92 w=0.65 l=0.15
X7 a_215_47# B2 a_78_199# VNB sky130_fd_pr__nfet_01v8 ad=0.11375 pd=1 as=0.08775 ps=0.92 w=0.65 l=0.15
X8 a_292_297# B1 VPWR VPB sky130_fd_pr__pfet_01v8_hvt ad=0.1175 pd=1.235 as=0.3725 ps=1.745 w=1 l=0.15
X9 VGND a_78_199# X VNB sky130_fd_pr__nfet_01v8 ad=0.169 pd=1.82 as=0.169 ps=1.82 w=0.65 l=0.15
.ends

.subckt sky130_fd_sc_hd__decap_8 VPWR VGND VPB VNB
X0 VPWR VGND VPWR VPB sky130_fd_pr__pfet_01v8_hvt ad=0.2262 pd=2.26 as=0.4524 ps=4.52 w=0.87 l=2.89
X1 VGND VPWR VGND VNB sky130_fd_pr__nfet_01v8 ad=0.143 pd=1.62 as=0.286 ps=3.24 w=0.55 l=2.89
.ends

.subckt sky130_fd_sc_hd__inv_1 VPB VNB VGND VPWR A Y
X0 Y A VGND VNB sky130_fd_pr__nfet_01v8 ad=0.169 pd=1.82 as=0.169 ps=1.82 w=0.65 l=0.15
X1 Y A VPWR VPB sky130_fd_pr__pfet_01v8_hvt ad=0.26 pd=2.52 as=0.26 ps=2.52 w=1 l=0.15
.ends

.subckt sky130_fd_sc_hd__nand2_1 VPB VNB VGND VPWR A Y B
X0 VPWR A Y VPB sky130_fd_pr__pfet_01v8_hvt ad=0.26 pd=2.52 as=0.135 ps=1.27 w=1 l=0.15
X1 Y A a_113_47# VNB sky130_fd_pr__nfet_01v8 ad=0.169 pd=1.82 as=0.08775 ps=0.92 w=0.65 l=0.15
X2 a_113_47# B VGND VNB sky130_fd_pr__nfet_01v8 ad=0.08775 pd=0.92 as=0.169 ps=1.82 w=0.65 l=0.15
X3 Y B VPWR VPB sky130_fd_pr__pfet_01v8_hvt ad=0.135 pd=1.27 as=0.26 ps=2.52 w=1 l=0.15
.ends

.subckt sky130_fd_sc_hd__xor2_1 VNB VPB VPWR VGND A X B
X0 X a_35_297# a_285_297# VPB sky130_fd_pr__pfet_01v8_hvt ad=0.3 pd=2.6 as=0.26 ps=2.52 w=1 l=0.15
X1 X B a_285_47# VNB sky130_fd_pr__nfet_01v8 ad=0.25025 pd=1.42 as=0.08775 ps=0.92 w=0.65 l=0.15
X2 a_35_297# B VGND VNB sky130_fd_pr__nfet_01v8 ad=0.08775 pd=0.92 as=0.169 ps=1.82 w=0.65 l=0.15
X3 a_117_297# B a_35_297# VPB sky130_fd_pr__pfet_01v8_hvt ad=0.135 pd=1.27 as=0.26 ps=2.52 w=1 l=0.15
X4 VPWR B a_285_297# VPB sky130_fd_pr__pfet_01v8_hvt ad=0.26 pd=2.52 as=0.135 ps=1.27 w=1 l=0.15
X5 VGND A a_35_297# VNB sky130_fd_pr__nfet_01v8 ad=0.08775 pd=0.92 as=0.08775 ps=0.92 w=0.65 l=0.15
X6 VGND a_35_297# X VNB sky130_fd_pr__nfet_01v8 ad=0.208 pd=1.94 as=0.25025 ps=1.42 w=0.65 l=0.15
X7 a_285_297# A VPWR VPB sky130_fd_pr__pfet_01v8_hvt ad=0.135 pd=1.27 as=0.135 ps=1.27 w=1 l=0.15
X8 VPWR A a_117_297# VPB sky130_fd_pr__pfet_01v8_hvt ad=0.135 pd=1.27 as=0.135 ps=1.27 w=1 l=0.15
X9 a_285_47# A VGND VNB sky130_fd_pr__nfet_01v8 ad=0.08775 pd=0.92 as=0.08775 ps=0.92 w=0.65 l=0.15
.ends

.subckt sky130_fd_sc_hd__dfstp_2 VPB VNB VPWR VGND Q SET_B D CLK
X0 VGND a_652_21# a_586_47# VNB sky130_fd_pr__nfet_01v8 ad=0.0882 pd=0.84 as=0.06705 ps=0.75 w=0.42 l=0.15
X1 a_956_413# a_476_47# VPWR VPB sky130_fd_pr__pfet_01v8_hvt ad=0.0441 pd=0.63 as=0.0567 ps=0.69 w=0.42 l=0.15
X2 a_1136_413# a_193_47# a_1028_413# VPB sky130_fd_pr__pfet_01v8_hvt ad=0.0441 pd=0.63 as=0.0819 ps=0.81 w=0.42 l=0.15
X3 VPWR a_476_47# a_652_21# VPB sky130_fd_pr__pfet_01v8_hvt ad=0.0567 pd=0.69 as=0.0567 ps=0.69 w=0.42 l=0.15
X4 a_1228_47# a_27_47# a_1028_413# VNB sky130_fd_pr__nfet_01v8 ad=0.0441 pd=0.63 as=0.0735 ps=0.77 w=0.42 l=0.15
X5 VPWR CLK a_27_47# VPB sky130_fd_pr__pfet_01v8_hvt ad=0.0864 pd=0.91 as=0.1664 ps=1.8 w=0.64 l=0.15
X6 a_586_47# a_193_47# a_476_47# VNB sky130_fd_pr__special_nfet_01v8 ad=0.06705 pd=0.75 as=0.072 ps=0.76 w=0.36 l=0.15
X7 a_1056_47# a_476_47# VGND VNB sky130_fd_pr__nfet_01v8 ad=0.0441 pd=0.63 as=0.1092 ps=1.36 w=0.42 l=0.15
X8 a_476_47# a_27_47# a_381_47# VNB sky130_fd_pr__special_nfet_01v8 ad=0.072 pd=0.76 as=0.0935 ps=0.965 w=0.36 l=0.15
X9 a_381_47# D VPWR VPB sky130_fd_pr__pfet_01v8_hvt ad=0.12495 pd=1.175 as=0.2184 ps=2.2 w=0.84 l=0.15
X10 a_652_21# SET_B VPWR VPB sky130_fd_pr__pfet_01v8_hvt ad=0.0567 pd=0.69 as=0.0798 ps=0.8 w=0.42 l=0.15
X11 VPWR a_1602_47# Q VPB sky130_fd_pr__pfet_01v8_hvt ad=0.26 pd=2.52 as=0.135 ps=1.27 w=1 l=0.15
X12 a_562_413# a_27_47# a_476_47# VPB sky130_fd_pr__pfet_01v8_hvt ad=0.0945 pd=0.87 as=0.0567 ps=0.69 w=0.42 l=0.15
X13 VGND a_1028_413# a_1602_47# VNB sky130_fd_pr__nfet_01v8 ad=0.08775 pd=0.92 as=0.169 ps=1.82 w=0.65 l=0.15
X14 VGND a_1602_47# Q VNB sky130_fd_pr__nfet_01v8 ad=0.169 pd=1.82 as=0.08775 ps=0.92 w=0.65 l=0.15
X15 Q a_1602_47# VPWR VPB sky130_fd_pr__pfet_01v8_hvt ad=0.135 pd=1.27 as=0.135 ps=1.27 w=1 l=0.15
X16 a_1028_413# a_193_47# a_1056_47# VNB sky130_fd_pr__nfet_01v8 ad=0.0735 pd=0.77 as=0.0441 ps=0.63 w=0.42 l=0.15
X17 a_476_47# a_193_47# a_381_47# VPB sky130_fd_pr__pfet_01v8_hvt ad=0.0567 pd=0.69 as=0.12495 ps=1.175 w=0.42 l=0.15
X18 a_193_47# a_27_47# VGND VNB sky130_fd_pr__nfet_01v8 ad=0.1092 pd=1.36 as=0.0567 ps=0.69 w=0.42 l=0.15
X19 VPWR a_1028_413# a_1602_47# VPB sky130_fd_pr__pfet_01v8_hvt ad=0.135 pd=1.27 as=0.26 ps=2.52 w=1 l=0.15
X20 VPWR a_652_21# a_562_413# VPB sky130_fd_pr__pfet_01v8_hvt ad=0.0798 pd=0.8 as=0.0945 ps=0.87 w=0.42 l=0.15
X21 Q a_1602_47# VGND VNB sky130_fd_pr__nfet_01v8 ad=0.08775 pd=0.92 as=0.08775 ps=0.92 w=0.65 l=0.15
X22 a_1028_413# a_27_47# a_956_413# VPB sky130_fd_pr__pfet_01v8_hvt ad=0.0819 pd=0.81 as=0.0441 ps=0.63 w=0.42 l=0.15
X23 VPWR a_1178_261# a_1136_413# VPB sky130_fd_pr__pfet_01v8_hvt ad=0.1092 pd=1.36 as=0.0441 ps=0.63 w=0.42 l=0.15
X24 a_193_47# a_27_47# VPWR VPB sky130_fd_pr__pfet_01v8_hvt ad=0.1664 pd=1.8 as=0.0864 ps=0.91 w=0.64 l=0.15
X25 a_1178_261# a_1028_413# VPWR VPB sky130_fd_pr__pfet_01v8_hvt ad=0.2226 pd=2.21 as=0.12075 ps=1.165 w=0.84 l=0.15
X26 a_796_47# SET_B VGND VNB sky130_fd_pr__nfet_01v8 ad=0.0441 pd=0.63 as=0.0882 ps=0.84 w=0.42 l=0.15
X27 a_1300_47# a_1178_261# a_1228_47# VNB sky130_fd_pr__nfet_01v8 ad=0.0441 pd=0.63 as=0.0441 ps=0.63 w=0.42 l=0.15
X28 a_381_47# D VGND VNB sky130_fd_pr__nfet_01v8 ad=0.0935 pd=0.965 as=0.1664 ps=1.8 w=0.64 l=0.15
X29 a_1178_261# a_1028_413# VGND VNB sky130_fd_pr__nfet_01v8 ad=0.1404 pd=1.6 as=0.1137 ps=1.01 w=0.54 l=0.15
X30 a_652_21# a_476_47# a_796_47# VNB sky130_fd_pr__nfet_01v8 ad=0.1092 pd=1.36 as=0.0441 ps=0.63 w=0.42 l=0.15
X31 VPWR SET_B a_1028_413# VPB sky130_fd_pr__pfet_01v8_hvt ad=0.12075 pd=1.165 as=0.1092 ps=1.36 w=0.42 l=0.15
X32 VGND CLK a_27_47# VNB sky130_fd_pr__nfet_01v8 ad=0.0567 pd=0.69 as=0.1092 ps=1.36 w=0.42 l=0.15
X33 VGND SET_B a_1300_47# VNB sky130_fd_pr__nfet_01v8 ad=0.1137 pd=1.01 as=0.0441 ps=0.63 w=0.42 l=0.15
.ends

.subckt sky130_fd_sc_hd__xnor2_1 VGND VPWR B Y A VPB VNB
X0 a_377_297# A VPWR VPB sky130_fd_pr__pfet_01v8_hvt ad=0.105 pd=1.21 as=0.365 ps=1.73 w=1 l=0.15
X1 a_47_47# B VPWR VPB sky130_fd_pr__pfet_01v8_hvt ad=0.135 pd=1.27 as=0.3 ps=2.6 w=1 l=0.15
X2 a_129_47# B a_47_47# VNB sky130_fd_pr__nfet_01v8 ad=0.06825 pd=0.86 as=0.169 ps=1.82 w=0.65 l=0.15
X3 a_285_47# B VGND VNB sky130_fd_pr__nfet_01v8 ad=0.08775 pd=0.92 as=0.169 ps=1.82 w=0.65 l=0.15
X4 Y a_47_47# a_285_47# VNB sky130_fd_pr__nfet_01v8 ad=0.195 pd=1.9 as=0.08775 ps=0.92 w=0.65 l=0.15
X5 VGND A a_129_47# VNB sky130_fd_pr__nfet_01v8 ad=0.08775 pd=0.92 as=0.06825 ps=0.86 w=0.65 l=0.15
X6 VPWR A a_47_47# VPB sky130_fd_pr__pfet_01v8_hvt ad=0.365 pd=1.73 as=0.135 ps=1.27 w=1 l=0.15
X7 VPWR a_47_47# Y VPB sky130_fd_pr__pfet_01v8_hvt ad=0.36 pd=2.72 as=0.165 ps=1.33 w=1 l=0.15
X8 Y B a_377_297# VPB sky130_fd_pr__pfet_01v8_hvt ad=0.165 pd=1.33 as=0.105 ps=1.21 w=1 l=0.15
X9 a_285_47# A VGND VNB sky130_fd_pr__nfet_01v8 ad=0.169 pd=1.82 as=0.08775 ps=0.92 w=0.65 l=0.15
.ends

.subckt sky130_fd_sc_hd__o32a_1 VPB VNB VPWR VGND X A1 A2 A3 B2 B1
X0 a_77_199# B2 a_227_47# VNB sky130_fd_pr__nfet_01v8 ad=0.13325 pd=1.06 as=0.12675 ps=1.04 w=0.65 l=0.15
X1 a_323_297# A2 a_227_297# VPB sky130_fd_pr__pfet_01v8_hvt ad=0.195 pd=1.39 as=0.165 ps=1.33 w=1 l=0.15
X2 a_227_297# A1 VPWR VPB sky130_fd_pr__pfet_01v8_hvt ad=0.165 pd=1.33 as=0.135 ps=1.27 w=1 l=0.15
X3 a_227_47# B1 a_77_199# VNB sky130_fd_pr__nfet_01v8 ad=0.1885 pd=1.88 as=0.13325 ps=1.06 w=0.65 l=0.15
X4 VGND a_77_199# X VNB sky130_fd_pr__nfet_01v8 ad=0.08775 pd=0.92 as=0.169 ps=1.82 w=0.65 l=0.15
X5 VPWR B1 a_539_297# VPB sky130_fd_pr__pfet_01v8_hvt ad=0.29 pd=2.58 as=0.205 ps=1.41 w=1 l=0.15
X6 a_227_47# A3 VGND VNB sky130_fd_pr__nfet_01v8 ad=0.12675 pd=1.04 as=0.12675 ps=1.04 w=0.65 l=0.15
X7 VPWR a_77_199# X VPB sky130_fd_pr__pfet_01v8_hvt ad=0.135 pd=1.27 as=0.335 ps=2.67 w=1 l=0.15
X8 a_77_199# A3 a_323_297# VPB sky130_fd_pr__pfet_01v8_hvt ad=0.195 pd=1.39 as=0.195 ps=1.39 w=1 l=0.15
X9 VGND A2 a_227_47# VNB sky130_fd_pr__nfet_01v8 ad=0.12675 pd=1.04 as=0.10725 ps=0.98 w=0.65 l=0.15
X10 a_227_47# A1 VGND VNB sky130_fd_pr__nfet_01v8 ad=0.10725 pd=0.98 as=0.08775 ps=0.92 w=0.65 l=0.15
X11 a_539_297# B2 a_77_199# VPB sky130_fd_pr__pfet_01v8_hvt ad=0.205 pd=1.41 as=0.195 ps=1.39 w=1 l=0.15
.ends

.subckt sky130_fd_sc_hd__a21boi_0 VNB VPB VPWR VGND A1 A2 B1_N Y
X0 a_300_369# A2 VPWR VPB sky130_fd_pr__pfet_01v8_hvt ad=0.1696 pd=1.81 as=0.0896 ps=0.92 w=0.64 l=0.15
X1 a_400_47# A1 Y VNB sky130_fd_pr__nfet_01v8 ad=0.0441 pd=0.63 as=0.1113 ps=0.95 w=0.42 l=0.15
X2 VGND A2 a_400_47# VNB sky130_fd_pr__nfet_01v8 ad=0.1113 pd=1.37 as=0.0441 ps=0.63 w=0.42 l=0.15
X3 VGND B1_N a_27_47# VNB sky130_fd_pr__nfet_01v8 ad=0.1302 pd=1.04 as=0.1113 ps=1.37 w=0.42 l=0.15
X4 VPWR B1_N a_27_47# VPB sky130_fd_pr__pfet_01v8_hvt ad=0.1113 pd=1.37 as=0.1113 ps=1.37 w=0.42 l=0.15
X5 Y a_27_47# VGND VNB sky130_fd_pr__nfet_01v8 ad=0.1113 pd=0.95 as=0.1302 ps=1.04 w=0.42 l=0.15
X6 a_300_369# a_27_47# Y VPB sky130_fd_pr__pfet_01v8_hvt ad=0.0896 pd=0.92 as=0.1696 ps=1.81 w=0.64 l=0.15
X7 VPWR A1 a_300_369# VPB sky130_fd_pr__pfet_01v8_hvt ad=0.0896 pd=0.92 as=0.0896 ps=0.92 w=0.64 l=0.15
.ends

.subckt sky130_fd_sc_hd__mux2_1 VGND VPWR VPB VNB X A1 S A0
X0 VPWR a_505_21# a_535_374# VPB sky130_fd_pr__pfet_01v8_hvt ad=0.0693 pd=0.75 as=0.0441 ps=0.63 w=0.42 l=0.15
X1 a_505_21# S VPWR VPB sky130_fd_pr__pfet_01v8_hvt ad=0.1176 pd=1.4 as=0.0693 ps=0.75 w=0.42 l=0.15
X2 a_218_374# S VPWR VPB sky130_fd_pr__pfet_01v8_hvt ad=0.07665 pd=0.785 as=0.15835 ps=1.395 w=0.42 l=0.15
X3 VGND a_505_21# a_439_47# VNB sky130_fd_pr__nfet_01v8 ad=0.1449 pd=1.11 as=0.0693 ps=0.75 w=0.42 l=0.15
X4 a_76_199# A0 a_218_374# VPB sky130_fd_pr__pfet_01v8_hvt ad=0.1932 pd=1.34 as=0.07665 ps=0.785 w=0.42 l=0.15
X5 a_505_21# S VGND VNB sky130_fd_pr__nfet_01v8 ad=0.1092 pd=1.36 as=0.1449 ps=1.11 w=0.42 l=0.15
X6 a_439_47# A0 a_76_199# VNB sky130_fd_pr__nfet_01v8 ad=0.0693 pd=0.75 as=0.09975 ps=0.895 w=0.42 l=0.15
X7 a_535_374# A1 a_76_199# VPB sky130_fd_pr__pfet_01v8_hvt ad=0.0441 pd=0.63 as=0.1932 ps=1.34 w=0.42 l=0.15
X8 a_76_199# A1 a_218_47# VNB sky130_fd_pr__nfet_01v8 ad=0.09975 pd=0.895 as=0.0693 ps=0.75 w=0.42 l=0.15
X9 a_218_47# S VGND VNB sky130_fd_pr__nfet_01v8 ad=0.0693 pd=0.75 as=0.11285 ps=1.045 w=0.42 l=0.15
X10 VPWR a_76_199# X VPB sky130_fd_pr__pfet_01v8_hvt ad=0.15835 pd=1.395 as=0.26 ps=2.52 w=1 l=0.15
X11 VGND a_76_199# X VNB sky130_fd_pr__nfet_01v8 ad=0.11285 pd=1.045 as=0.169 ps=1.82 w=0.65 l=0.15
.ends

.subckt sky130_fd_sc_hd__nor2_1 VPB VNB VGND VPWR A B Y
X0 VPWR A a_109_297# VPB sky130_fd_pr__pfet_01v8_hvt ad=0.26 pd=2.52 as=0.105 ps=1.21 w=1 l=0.15
X1 VGND A Y VNB sky130_fd_pr__nfet_01v8 ad=0.169 pd=1.82 as=0.08775 ps=0.92 w=0.65 l=0.15
X2 a_109_297# B Y VPB sky130_fd_pr__pfet_01v8_hvt ad=0.105 pd=1.21 as=0.26 ps=2.52 w=1 l=0.15
X3 Y B VGND VNB sky130_fd_pr__nfet_01v8 ad=0.08775 pd=0.92 as=0.169 ps=1.82 w=0.65 l=0.15
.ends

.subckt sky130_fd_sc_hd__mux2i_1 VPB VNB VGND VPWR A0 Y A1 S
X0 a_27_297# S VPWR VPB sky130_fd_pr__pfet_01v8_hvt ad=0.26 pd=2.52 as=0.3 ps=1.6 w=1 l=0.15
X1 VGND S a_283_205# VNB sky130_fd_pr__nfet_01v8 ad=0.169 pd=1.82 as=0.169 ps=1.82 w=0.65 l=0.15
X2 a_204_297# A1 Y VPB sky130_fd_pr__pfet_01v8_hvt ad=0.1975 pd=1.395 as=0.1525 ps=1.305 w=1 l=0.15
X3 a_193_47# A1 Y VNB sky130_fd_pr__nfet_01v8 ad=0.182 pd=1.86 as=0.08775 ps=0.92 w=0.65 l=0.15
X4 Y A0 a_27_297# VPB sky130_fd_pr__pfet_01v8_hvt ad=0.1525 pd=1.305 as=0.28 ps=2.56 w=1 l=0.15
X5 VPWR a_283_205# a_204_297# VPB sky130_fd_pr__pfet_01v8_hvt ad=0.3 pd=1.6 as=0.1975 ps=1.395 w=1 l=0.15
X6 VPWR S a_283_205# VPB sky130_fd_pr__pfet_01v8_hvt ad=0.26 pd=2.52 as=0.29 ps=2.58 w=1 l=0.15
X7 VGND a_283_205# a_27_47# VNB sky130_fd_pr__nfet_01v8 ad=0.08775 pd=0.92 as=0.169 ps=1.82 w=0.65 l=0.15
X8 a_193_47# S VGND VNB sky130_fd_pr__nfet_01v8 ad=0.169 pd=1.82 as=0.08775 ps=0.92 w=0.65 l=0.15
X9 Y A0 a_27_47# VNB sky130_fd_pr__nfet_01v8 ad=0.08775 pd=0.92 as=0.169 ps=1.82 w=0.65 l=0.15
.ends

.subckt sky130_fd_sc_hd__nor3_1 VPB VNB VGND VPWR C B A Y
X0 VPWR A a_193_297# VPB sky130_fd_pr__pfet_01v8_hvt ad=0.26 pd=2.52 as=0.135 ps=1.27 w=1 l=0.15
X1 a_193_297# B a_109_297# VPB sky130_fd_pr__pfet_01v8_hvt ad=0.135 pd=1.27 as=0.135 ps=1.27 w=1 l=0.15
X2 Y B VGND VNB sky130_fd_pr__nfet_01v8 ad=0.08775 pd=0.92 as=0.08775 ps=0.92 w=0.65 l=0.15
X3 VGND A Y VNB sky130_fd_pr__nfet_01v8 ad=0.169 pd=1.82 as=0.08775 ps=0.92 w=0.65 l=0.15
X4 a_109_297# C Y VPB sky130_fd_pr__pfet_01v8_hvt ad=0.135 pd=1.27 as=0.26 ps=2.52 w=1 l=0.15
X5 VGND C Y VNB sky130_fd_pr__nfet_01v8 ad=0.08775 pd=0.92 as=0.169 ps=1.82 w=0.65 l=0.15
.ends

.subckt sky130_fd_sc_hd__decap_4 VGND VPWR VPB VNB
X0 VPWR VGND VPWR VPB sky130_fd_pr__pfet_01v8_hvt ad=0.2262 pd=2.26 as=0.4524 ps=4.52 w=0.87 l=1.05
X1 VGND VPWR VGND VNB sky130_fd_pr__nfet_01v8 ad=0.143 pd=1.62 as=0.286 ps=3.24 w=0.55 l=1.05
.ends

.subckt sky130_fd_sc_hd__nor4_1 VPB VNB VGND VPWR Y D C B A
X0 Y B VGND VNB sky130_fd_pr__nfet_01v8 ad=0.08775 pd=0.92 as=0.08937 ps=0.925 w=0.65 l=0.15
X1 a_191_297# C a_109_297# VPB sky130_fd_pr__pfet_01v8_hvt ad=0.19 pd=1.38 as=0.13 ps=1.26 w=1 l=0.15
X2 VPWR A a_297_297# VPB sky130_fd_pr__pfet_01v8_hvt ad=0.26 pd=2.52 as=0.135 ps=1.27 w=1 l=0.15
X3 VGND C Y VNB sky130_fd_pr__nfet_01v8 ad=0.08937 pd=0.925 as=0.11863 ps=1.015 w=0.65 l=0.15
X4 VGND A Y VNB sky130_fd_pr__nfet_01v8 ad=0.169 pd=1.82 as=0.08775 ps=0.92 w=0.65 l=0.15
X5 a_297_297# B a_191_297# VPB sky130_fd_pr__pfet_01v8_hvt ad=0.135 pd=1.27 as=0.19 ps=1.38 w=1 l=0.15
X6 a_109_297# D Y VPB sky130_fd_pr__pfet_01v8_hvt ad=0.13 pd=1.26 as=0.26 ps=2.52 w=1 l=0.15
X7 Y D VGND VNB sky130_fd_pr__nfet_01v8 ad=0.11863 pd=1.015 as=0.169 ps=1.82 w=0.65 l=0.15
.ends

.subckt sky130_fd_sc_hd__nand3_1 VPB VNB VGND VPWR A B Y C
X0 VPWR B Y VPB sky130_fd_pr__pfet_01v8_hvt ad=0.165 pd=1.33 as=0.135 ps=1.27 w=1 l=0.15
X1 Y A VPWR VPB sky130_fd_pr__pfet_01v8_hvt ad=0.26 pd=2.52 as=0.165 ps=1.33 w=1 l=0.15
X2 a_193_47# B a_109_47# VNB sky130_fd_pr__nfet_01v8 ad=0.10725 pd=0.98 as=0.08775 ps=0.92 w=0.65 l=0.15
X3 Y A a_193_47# VNB sky130_fd_pr__nfet_01v8 ad=0.169 pd=1.82 as=0.10725 ps=0.98 w=0.65 l=0.15
X4 Y C VPWR VPB sky130_fd_pr__pfet_01v8_hvt ad=0.135 pd=1.27 as=0.26 ps=2.52 w=1 l=0.15
X5 a_109_47# C VGND VNB sky130_fd_pr__nfet_01v8 ad=0.08775 pd=0.92 as=0.169 ps=1.82 w=0.65 l=0.15
.ends

.subckt sky130_fd_sc_hd__a22o_1 VPWR VGND VPB VNB B1 A1 A2 X B2
X0 VPWR A2 a_109_297# VPB sky130_fd_pr__pfet_01v8_hvt ad=0.155 pd=1.31 as=0.16 ps=1.32 w=1 l=0.15
X1 a_27_297# B1 a_109_47# VNB sky130_fd_pr__nfet_01v8 ad=0.169 pd=1.82 as=0.07475 ps=0.88 w=0.65 l=0.15
X2 VGND A2 a_373_47# VNB sky130_fd_pr__nfet_01v8 ad=0.10075 pd=0.96 as=0.11375 ps=1 w=0.65 l=0.15
X3 X a_27_297# VPWR VPB sky130_fd_pr__pfet_01v8_hvt ad=0.26 pd=2.52 as=0.155 ps=1.31 w=1 l=0.15
X4 a_27_297# B1 a_109_297# VPB sky130_fd_pr__pfet_01v8_hvt ad=0.25285 pd=2.52 as=0.135 ps=1.27 w=1 l=0.15
X5 a_109_297# A1 VPWR VPB sky130_fd_pr__pfet_01v8_hvt ad=0.16 pd=1.32 as=0.2529 ps=2.52 w=1 l=0.15
X6 a_373_47# A1 a_27_297# VNB sky130_fd_pr__nfet_01v8 ad=0.11375 pd=1 as=0.169 ps=1.82 w=0.65 l=0.15
X7 X a_27_297# VGND VNB sky130_fd_pr__nfet_01v8 ad=0.169 pd=1.82 as=0.10075 ps=0.96 w=0.65 l=0.15
X8 a_109_297# B2 a_27_297# VPB sky130_fd_pr__pfet_01v8_hvt ad=0.135 pd=1.27 as=0.26 ps=2.52 w=1 l=0.15
X9 a_109_47# B2 VGND VNB sky130_fd_pr__nfet_01v8 ad=0.07475 pd=0.88 as=0.169 ps=1.82 w=0.65 l=0.15
.ends

.subckt sky130_fd_sc_hd__dfrtp_2 VGND VPWR VPB VNB CLK D RESET_B Q
X0 a_805_47# a_761_289# a_639_47# VNB sky130_fd_pr__nfet_01v8 ad=0.0441 pd=0.63 as=0.1401 ps=1.1 w=0.42 l=0.15
X1 a_1217_47# a_27_47# a_1108_47# VNB sky130_fd_pr__special_nfet_01v8 ad=0.0669 pd=0.75 as=0.0711 ps=0.755 w=0.36 l=0.15
X2 VGND a_1283_21# Q VNB sky130_fd_pr__nfet_01v8 ad=0.169 pd=1.82 as=0.08775 ps=0.92 w=0.65 l=0.15
X3 a_1283_21# a_1108_47# a_1462_47# VNB sky130_fd_pr__nfet_01v8 ad=0.1092 pd=1.36 as=0.06405 ps=0.725 w=0.42 l=0.15
X4 a_651_413# a_27_47# a_543_47# VPB sky130_fd_pr__pfet_01v8_hvt ad=0.1155 pd=0.97 as=0.07245 ps=0.765 w=0.42 l=0.15
X5 VPWR a_1283_21# Q VPB sky130_fd_pr__pfet_01v8_hvt ad=0.26 pd=2.52 as=0.135 ps=1.27 w=1 l=0.15
X6 a_1108_47# a_193_47# a_761_289# VNB sky130_fd_pr__special_nfet_01v8 ad=0.0711 pd=0.755 as=0.0999 ps=0.985 w=0.36 l=0.15
X7 VGND RESET_B a_805_47# VNB sky130_fd_pr__nfet_01v8 ad=0.1346 pd=1.15 as=0.0441 ps=0.63 w=0.42 l=0.15
X8 Q a_1283_21# VPWR VPB sky130_fd_pr__pfet_01v8_hvt ad=0.135 pd=1.27 as=0.3012 ps=2.66 w=1 l=0.15
X9 VPWR CLK a_27_47# VPB sky130_fd_pr__pfet_01v8_hvt ad=0.0864 pd=0.91 as=0.1664 ps=1.8 w=0.64 l=0.15
X10 a_448_47# D VPWR VPB sky130_fd_pr__pfet_01v8_hvt ad=0.0651 pd=0.73 as=0.1092 ps=1.36 w=0.42 l=0.15
X11 a_761_289# a_543_47# VGND VNB sky130_fd_pr__nfet_01v8 ad=0.0999 pd=0.985 as=0.1346 ps=1.15 w=0.64 l=0.15
X12 a_193_47# a_27_47# VGND VNB sky130_fd_pr__nfet_01v8 ad=0.1092 pd=1.36 as=0.0567 ps=0.69 w=0.42 l=0.15
X13 a_1108_47# a_27_47# a_761_289# VPB sky130_fd_pr__pfet_01v8_hvt ad=0.0588 pd=0.7 as=0.12915 ps=1.185 w=0.42 l=0.15
X14 a_1462_47# RESET_B VGND VNB sky130_fd_pr__nfet_01v8 ad=0.06405 pd=0.725 as=0.12495 ps=1.015 w=0.42 l=0.15
X15 a_543_47# a_27_47# a_448_47# VNB sky130_fd_pr__special_nfet_01v8 ad=0.0594 pd=0.69 as=0.066 ps=0.745 w=0.36 l=0.15
X16 a_543_47# a_193_47# a_448_47# VPB sky130_fd_pr__pfet_01v8_hvt ad=0.07245 pd=0.765 as=0.0651 ps=0.73 w=0.42 l=0.15
X17 a_448_47# D VGND VNB sky130_fd_pr__nfet_01v8 ad=0.066 pd=0.745 as=0.2205 ps=1.89 w=0.42 l=0.15
X18 VPWR a_1283_21# a_1270_413# VPB sky130_fd_pr__pfet_01v8_hvt ad=0.0819 pd=0.81 as=0.0567 ps=0.69 w=0.42 l=0.15
X19 VPWR a_1108_47# a_1283_21# VPB sky130_fd_pr__pfet_01v8_hvt ad=0.1134 pd=1.38 as=0.0567 ps=0.69 w=0.42 l=0.15
X20 a_1270_413# a_193_47# a_1108_47# VPB sky130_fd_pr__pfet_01v8_hvt ad=0.0567 pd=0.69 as=0.0588 ps=0.7 w=0.42 l=0.15
X21 a_193_47# a_27_47# VPWR VPB sky130_fd_pr__pfet_01v8_hvt ad=0.1664 pd=1.8 as=0.0864 ps=0.91 w=0.64 l=0.15
X22 a_1283_21# RESET_B VPWR VPB sky130_fd_pr__pfet_01v8_hvt ad=0.0567 pd=0.69 as=0.0819 ps=0.81 w=0.42 l=0.15
X23 VPWR a_761_289# a_651_413# VPB sky130_fd_pr__pfet_01v8_hvt ad=0.07035 pd=0.755 as=0.1155 ps=0.97 w=0.42 l=0.15
X24 Q a_1283_21# VGND VNB sky130_fd_pr__nfet_01v8 ad=0.08775 pd=0.92 as=0.2087 ps=2.02 w=0.65 l=0.15
X25 a_639_47# a_193_47# a_543_47# VNB sky130_fd_pr__special_nfet_01v8 ad=0.1401 pd=1.1 as=0.0594 ps=0.69 w=0.36 l=0.15
X26 VGND a_1283_21# a_1217_47# VNB sky130_fd_pr__nfet_01v8 ad=0.12495 pd=1.015 as=0.0669 ps=0.75 w=0.42 l=0.15
X27 a_651_413# RESET_B VPWR VPB sky130_fd_pr__pfet_01v8_hvt ad=0.1092 pd=1.36 as=0.07035 ps=0.755 w=0.42 l=0.15
X28 VGND CLK a_27_47# VNB sky130_fd_pr__nfet_01v8 ad=0.0567 pd=0.69 as=0.1092 ps=1.36 w=0.42 l=0.15
X29 a_761_289# a_543_47# VPWR VPB sky130_fd_pr__pfet_01v8_hvt ad=0.12915 pd=1.185 as=0.2184 ps=2.2 w=0.84 l=0.15
.ends

.subckt sky130_fd_sc_hd__a41oi_1 VGND VPWR A4 Y B1 A1 A2 A3 VPB VNB
X0 a_236_47# A4 VGND VNB sky130_fd_pr__nfet_01v8 ad=0.11375 pd=1 as=0.16342 ps=1.175 w=0.65 l=0.15
X1 a_428_47# A2 a_336_47# VNB sky130_fd_pr__nfet_01v8 ad=0.13813 pd=1.075 as=0.10075 ps=0.96 w=0.65 l=0.15
X2 a_109_297# A1 VPWR VPB sky130_fd_pr__pfet_01v8_hvt ad=0.37 pd=2.74 as=0.2125 ps=1.425 w=1 l=0.15
X3 Y A1 a_428_47# VNB sky130_fd_pr__nfet_01v8 ad=0.2405 pd=2.04 as=0.13813 ps=1.075 w=0.65 l=0.15
X4 a_336_47# A3 a_236_47# VNB sky130_fd_pr__nfet_01v8 ad=0.10075 pd=0.96 as=0.11375 ps=1 w=0.65 l=0.15
X5 VPWR A4 a_109_297# VPB sky130_fd_pr__pfet_01v8_hvt ad=0.205 pd=1.41 as=0.2125 ps=1.425 w=1 l=0.15
X6 a_109_297# B1 Y VPB sky130_fd_pr__pfet_01v8_hvt ad=0.2125 pd=1.425 as=0.26 ps=2.52 w=1 l=0.15
X7 a_109_297# A3 VPWR VPB sky130_fd_pr__pfet_01v8_hvt ad=0.155 pd=1.31 as=0.205 ps=1.41 w=1 l=0.15
X8 VPWR A2 a_109_297# VPB sky130_fd_pr__pfet_01v8_hvt ad=0.2125 pd=1.425 as=0.155 ps=1.31 w=1 l=0.15
X9 VGND B1 Y VNB sky130_fd_pr__nfet_01v8 ad=0.16342 pd=1.175 as=0.169 ps=1.82 w=0.65 l=0.15
.ends

.subckt sky130_fd_sc_hd__a211oi_1 VPWR VGND VPB VNB Y C1 B1 A1 A2
X0 a_56_297# A1 VPWR VPB sky130_fd_pr__pfet_01v8_hvt ad=0.14 pd=1.28 as=0.14 ps=1.28 w=1 l=0.15
X1 VPWR A2 a_56_297# VPB sky130_fd_pr__pfet_01v8_hvt ad=0.14 pd=1.28 as=0.265 ps=2.53 w=1 l=0.15
X2 Y C1 VGND VNB sky130_fd_pr__nfet_01v8 ad=0.17225 pd=1.83 as=0.10075 ps=0.96 w=0.65 l=0.15
X3 a_139_47# A2 VGND VNB sky130_fd_pr__nfet_01v8 ad=0.091 pd=0.93 as=0.2665 ps=2.12 w=0.65 l=0.15
X4 a_311_297# B1 a_56_297# VPB sky130_fd_pr__pfet_01v8_hvt ad=0.155 pd=1.31 as=0.14 ps=1.28 w=1 l=0.15
X5 Y C1 a_311_297# VPB sky130_fd_pr__pfet_01v8_hvt ad=0.265 pd=2.53 as=0.155 ps=1.31 w=1 l=0.15
X6 VGND B1 Y VNB sky130_fd_pr__nfet_01v8 ad=0.10075 pd=0.96 as=0.091 ps=0.93 w=0.65 l=0.15
X7 Y A1 a_139_47# VNB sky130_fd_pr__nfet_01v8 ad=0.091 pd=0.93 as=0.091 ps=0.93 w=0.65 l=0.15
.ends

.subckt sky130_fd_sc_hd__buf_4 VPWR VGND X A VPB VNB
X0 VPWR a_27_47# X VPB sky130_fd_pr__pfet_01v8_hvt ad=0.26 pd=2.52 as=0.135 ps=1.27 w=1 l=0.15
X1 X a_27_47# VPWR VPB sky130_fd_pr__pfet_01v8_hvt ad=0.135 pd=1.27 as=0.135 ps=1.27 w=1 l=0.15
X2 VPWR a_27_47# X VPB sky130_fd_pr__pfet_01v8_hvt ad=0.135 pd=1.27 as=0.135 ps=1.27 w=1 l=0.15
X3 X a_27_47# VPWR VPB sky130_fd_pr__pfet_01v8_hvt ad=0.135 pd=1.27 as=0.135 ps=1.27 w=1 l=0.15
X4 X a_27_47# VGND VNB sky130_fd_pr__nfet_01v8 ad=0.08775 pd=0.92 as=0.08775 ps=0.92 w=0.65 l=0.15
X5 X a_27_47# VGND VNB sky130_fd_pr__nfet_01v8 ad=0.08775 pd=0.92 as=0.08775 ps=0.92 w=0.65 l=0.15
X6 VGND a_27_47# X VNB sky130_fd_pr__nfet_01v8 ad=0.08775 pd=0.92 as=0.08775 ps=0.92 w=0.65 l=0.15
X7 VGND a_27_47# X VNB sky130_fd_pr__nfet_01v8 ad=0.169 pd=1.82 as=0.08775 ps=0.92 w=0.65 l=0.15
X8 VPWR A a_27_47# VPB sky130_fd_pr__pfet_01v8_hvt ad=0.135 pd=1.27 as=0.26 ps=2.52 w=1 l=0.15
X9 VGND A a_27_47# VNB sky130_fd_pr__nfet_01v8 ad=0.08775 pd=0.92 as=0.169 ps=1.82 w=0.65 l=0.15
.ends

.subckt sky130_fd_sc_hd__and2_0 VNB VPB VPWR VGND X B A
X0 VPWR B a_40_47# VPB sky130_fd_pr__pfet_01v8_hvt ad=0.1841 pd=1.26 as=0.0609 ps=0.71 w=0.42 l=0.15
X1 X a_40_47# VPWR VPB sky130_fd_pr__pfet_01v8_hvt ad=0.1696 pd=1.81 as=0.1841 ps=1.26 w=0.64 l=0.15
X2 VGND B a_123_47# VNB sky130_fd_pr__nfet_01v8 ad=0.0966 pd=0.88 as=0.0441 ps=0.63 w=0.42 l=0.15
X3 X a_40_47# VGND VNB sky130_fd_pr__nfet_01v8 ad=0.1113 pd=1.37 as=0.0966 ps=0.88 w=0.42 l=0.15
X4 a_123_47# A a_40_47# VNB sky130_fd_pr__nfet_01v8 ad=0.0441 pd=0.63 as=0.1113 ps=1.37 w=0.42 l=0.15
X5 a_40_47# A VPWR VPB sky130_fd_pr__pfet_01v8_hvt ad=0.0609 pd=0.71 as=0.1113 ps=1.37 w=0.42 l=0.15
.ends

.subckt sky130_fd_sc_hd__and3_1 VGND VPWR X B A C VPB VNB
X0 VPWR A a_27_47# VPB sky130_fd_pr__pfet_01v8_hvt ad=0.0567 pd=0.69 as=0.1092 ps=1.36 w=0.42 l=0.15
X1 VPWR C a_27_47# VPB sky130_fd_pr__pfet_01v8_hvt ad=0.14222 pd=1.335 as=0.06615 ps=0.735 w=0.42 l=0.15
X2 a_181_47# B a_109_47# VNB sky130_fd_pr__nfet_01v8 ad=0.0441 pd=0.63 as=0.0441 ps=0.63 w=0.42 l=0.15
X3 VGND C a_181_47# VNB sky130_fd_pr__nfet_01v8 ad=0.13165 pd=1.14 as=0.0441 ps=0.63 w=0.42 l=0.15
X4 a_27_47# B VPWR VPB sky130_fd_pr__pfet_01v8_hvt ad=0.06615 pd=0.735 as=0.0567 ps=0.69 w=0.42 l=0.15
X5 X a_27_47# VPWR VPB sky130_fd_pr__pfet_01v8_hvt ad=0.26 pd=2.52 as=0.14222 ps=1.335 w=1 l=0.15
X6 X a_27_47# VGND VNB sky130_fd_pr__nfet_01v8 ad=0.169 pd=1.82 as=0.13165 ps=1.14 w=0.65 l=0.15
X7 a_109_47# A a_27_47# VNB sky130_fd_pr__nfet_01v8 ad=0.0441 pd=0.63 as=0.1092 ps=1.36 w=0.42 l=0.15
.ends

.subckt sky130_fd_sc_hd__o31ai_1 VPB VNB A1 A2 A3 Y B1 VPWR VGND
X0 Y B1 a_109_47# VNB sky130_fd_pr__nfet_01v8 ad=0.221 pd=1.98 as=0.19825 ps=1.26 w=0.65 l=0.15
X1 Y A3 a_193_297# VPB sky130_fd_pr__pfet_01v8_hvt ad=0.3925 pd=1.785 as=0.135 ps=1.27 w=1 l=0.15
X2 a_193_297# A2 a_109_297# VPB sky130_fd_pr__pfet_01v8_hvt ad=0.135 pd=1.27 as=0.135 ps=1.27 w=1 l=0.15
X3 VGND A2 a_109_47# VNB sky130_fd_pr__nfet_01v8 ad=0.08775 pd=0.92 as=0.08775 ps=0.92 w=0.65 l=0.15
X4 VPWR B1 Y VPB sky130_fd_pr__pfet_01v8_hvt ad=0.3 pd=2.6 as=0.3925 ps=1.785 w=1 l=0.15
X5 a_109_47# A3 VGND VNB sky130_fd_pr__nfet_01v8 ad=0.19825 pd=1.26 as=0.08775 ps=0.92 w=0.65 l=0.15
X6 a_109_297# A1 VPWR VPB sky130_fd_pr__pfet_01v8_hvt ad=0.135 pd=1.27 as=0.26 ps=2.52 w=1 l=0.15
X7 a_109_47# A1 VGND VNB sky130_fd_pr__nfet_01v8 ad=0.08775 pd=0.92 as=0.169 ps=1.82 w=0.65 l=0.15
.ends

.subckt sky130_fd_sc_hd__o22ai_1 VPB VNB VGND VPWR A1 A2 B1 B2 Y
X0 VGND A2 a_27_47# VNB sky130_fd_pr__nfet_01v8 ad=0.08775 pd=0.92 as=0.11537 ps=1.005 w=0.65 l=0.15
X1 a_27_47# B2 Y VNB sky130_fd_pr__nfet_01v8 ad=0.11537 pd=1.005 as=0.09262 ps=0.935 w=0.65 l=0.15
X2 VPWR A1 a_307_297# VPB sky130_fd_pr__pfet_01v8_hvt ad=0.27 pd=2.54 as=0.105 ps=1.21 w=1 l=0.15
X3 a_307_297# A2 Y VPB sky130_fd_pr__pfet_01v8_hvt ad=0.105 pd=1.21 as=0.2325 ps=1.465 w=1 l=0.15
X4 a_27_47# A1 VGND VNB sky130_fd_pr__nfet_01v8 ad=0.169 pd=1.82 as=0.08775 ps=0.92 w=0.65 l=0.15
X5 Y B2 a_109_297# VPB sky130_fd_pr__pfet_01v8_hvt ad=0.2325 pd=1.465 as=0.1125 ps=1.225 w=1 l=0.15
X6 a_109_297# B1 VPWR VPB sky130_fd_pr__pfet_01v8_hvt ad=0.1125 pd=1.225 as=0.26 ps=2.52 w=1 l=0.15
X7 Y B1 a_27_47# VNB sky130_fd_pr__nfet_01v8 ad=0.09262 pd=0.935 as=0.169 ps=1.82 w=0.65 l=0.15
.ends

.subckt sky130_fd_sc_hd__a32o_1 VGND VPWR VPB VNB X A3 A2 A1 B1 B2
X0 a_93_21# A1 a_346_47# VNB sky130_fd_pr__nfet_01v8 ad=0.143 pd=1.09 as=0.14625 ps=1.1 w=0.65 l=0.15
X1 a_93_21# B1 a_250_297# VPB sky130_fd_pr__pfet_01v8_hvt ad=0.14 pd=1.28 as=0.185 ps=1.37 w=1 l=0.15
X2 a_584_47# B1 a_93_21# VNB sky130_fd_pr__nfet_01v8 ad=0.06825 pd=0.86 as=0.143 ps=1.09 w=0.65 l=0.15
X3 VPWR a_93_21# X VPB sky130_fd_pr__pfet_01v8_hvt ad=0.2425 pd=1.485 as=0.33 ps=2.66 w=1 l=0.15
X4 VGND B2 a_584_47# VNB sky130_fd_pr__nfet_01v8 ad=0.17225 pd=1.83 as=0.06825 ps=0.86 w=0.65 l=0.15
X5 a_256_47# A3 VGND VNB sky130_fd_pr__nfet_01v8 ad=0.0975 pd=0.95 as=0.16737 ps=1.165 w=0.65 l=0.15
X6 a_250_297# B2 a_93_21# VPB sky130_fd_pr__pfet_01v8_hvt ad=0.265 pd=2.53 as=0.14 ps=1.28 w=1 l=0.15
X7 VGND a_93_21# X VNB sky130_fd_pr__nfet_01v8 ad=0.16737 pd=1.165 as=0.2145 ps=1.96 w=0.65 l=0.15
X8 a_250_297# A3 VPWR VPB sky130_fd_pr__pfet_01v8_hvt ad=0.165 pd=1.33 as=0.2425 ps=1.485 w=1 l=0.15
X9 VPWR A2 a_250_297# VPB sky130_fd_pr__pfet_01v8_hvt ad=0.225 pd=1.45 as=0.165 ps=1.33 w=1 l=0.15
X10 a_250_297# A1 VPWR VPB sky130_fd_pr__pfet_01v8_hvt ad=0.185 pd=1.37 as=0.225 ps=1.45 w=1 l=0.15
X11 a_346_47# A2 a_256_47# VNB sky130_fd_pr__nfet_01v8 ad=0.14625 pd=1.1 as=0.0975 ps=0.95 w=0.65 l=0.15
.ends

.subckt sky130_fd_sc_hd__o311ai_1 Y C1 B1 A3 A2 A1 VPB VNB VGND VPWR
X0 VGND A2 a_138_47# VNB sky130_fd_pr__nfet_01v8 ad=0.08775 pd=0.92 as=0.08775 ps=0.92 w=0.65 l=0.15
X1 a_138_47# A1 VGND VNB sky130_fd_pr__nfet_01v8 ad=0.08775 pd=0.92 as=0.182 ps=1.86 w=0.65 l=0.15
X2 Y C1 VPWR VPB sky130_fd_pr__pfet_01v8_hvt ad=0.31 pd=2.62 as=0.185 ps=1.37 w=1 l=0.15
X3 a_138_47# A3 VGND VNB sky130_fd_pr__nfet_01v8 ad=0.19825 pd=1.26 as=0.08775 ps=0.92 w=0.65 l=0.15
X4 Y A3 a_222_297# VPB sky130_fd_pr__pfet_01v8_hvt ad=0.225 pd=1.45 as=0.135 ps=1.27 w=1 l=0.15
X5 Y C1 a_458_47# VNB sky130_fd_pr__nfet_01v8 ad=0.182 pd=1.86 as=0.06825 ps=0.86 w=0.65 l=0.15
X6 a_222_297# A2 a_138_297# VPB sky130_fd_pr__pfet_01v8_hvt ad=0.135 pd=1.27 as=0.135 ps=1.27 w=1 l=0.15
X7 VPWR B1 Y VPB sky130_fd_pr__pfet_01v8_hvt ad=0.185 pd=1.37 as=0.225 ps=1.45 w=1 l=0.15
X8 a_458_47# B1 a_138_47# VNB sky130_fd_pr__nfet_01v8 ad=0.06825 pd=0.86 as=0.19825 ps=1.26 w=0.65 l=0.15
X9 a_138_297# A1 VPWR VPB sky130_fd_pr__pfet_01v8_hvt ad=0.135 pd=1.27 as=0.28 ps=2.56 w=1 l=0.15
.ends

.subckt sky130_fd_sc_hd__a22oi_1 VPWR VGND VPB VNB B2 B1 Y A1 A2
X0 Y B1 a_109_47# VNB sky130_fd_pr__nfet_01v8 ad=0.169 pd=1.82 as=0.07475 ps=0.88 w=0.65 l=0.15
X1 Y B1 a_109_297# VPB sky130_fd_pr__pfet_01v8_hvt ad=0.26 pd=2.52 as=0.135 ps=1.27 w=1 l=0.15
X2 VPWR A2 a_109_297# VPB sky130_fd_pr__pfet_01v8_hvt ad=0.3 pd=2.6 as=0.135 ps=1.27 w=1 l=0.15
X3 a_109_297# A1 VPWR VPB sky130_fd_pr__pfet_01v8_hvt ad=0.135 pd=1.27 as=0.26 ps=2.52 w=1 l=0.15
X4 a_381_47# A1 Y VNB sky130_fd_pr__nfet_01v8 ad=0.06825 pd=0.86 as=0.169 ps=1.82 w=0.65 l=0.15
X5 a_109_297# B2 Y VPB sky130_fd_pr__pfet_01v8_hvt ad=0.135 pd=1.27 as=0.26 ps=2.52 w=1 l=0.15
X6 a_109_47# B2 VGND VNB sky130_fd_pr__nfet_01v8 ad=0.07475 pd=0.88 as=0.169 ps=1.82 w=0.65 l=0.15
X7 VGND A2 a_381_47# VNB sky130_fd_pr__nfet_01v8 ad=0.234 pd=2.02 as=0.06825 ps=0.86 w=0.65 l=0.15
.ends

.subckt sky130_fd_sc_hd__nor2b_1 VPB VNB VGND VPWR B_N A Y
X0 Y a_74_47# a_265_297# VPB sky130_fd_pr__pfet_01v8_hvt ad=0.26 pd=2.52 as=0.105 ps=1.21 w=1 l=0.15
X1 VPWR B_N a_74_47# VPB sky130_fd_pr__pfet_01v8_hvt ad=0.1573 pd=1.39 as=0.1092 ps=1.36 w=0.42 l=0.15
X2 a_265_297# A VPWR VPB sky130_fd_pr__pfet_01v8_hvt ad=0.105 pd=1.21 as=0.1573 ps=1.39 w=1 l=0.15
X3 Y A VGND VNB sky130_fd_pr__nfet_01v8 ad=0.08775 pd=0.92 as=0.10025 ps=0.985 w=0.65 l=0.15
X4 VGND B_N a_74_47# VNB sky130_fd_pr__nfet_01v8 ad=0.10025 pd=0.985 as=0.1092 ps=1.36 w=0.42 l=0.15
X5 VGND a_74_47# Y VNB sky130_fd_pr__nfet_01v8 ad=0.169 pd=1.82 as=0.08775 ps=0.92 w=0.65 l=0.15
.ends

.subckt sky130_fd_sc_hd__a31oi_1 VGND VPWR VPB VNB A3 A2 A1 Y B1
X0 Y A1 a_181_47# VNB sky130_fd_pr__nfet_01v8 ad=0.10563 pd=0.975 as=0.11863 ps=1.015 w=0.65 l=0.15
X1 a_181_47# A2 a_109_47# VNB sky130_fd_pr__nfet_01v8 ad=0.11863 pd=1.015 as=0.06825 ps=0.86 w=0.65 l=0.15
X2 VGND B1 Y VNB sky130_fd_pr__nfet_01v8 ad=0.1755 pd=1.84 as=0.10563 ps=0.975 w=0.65 l=0.15
X3 VPWR A2 a_109_297# VPB sky130_fd_pr__pfet_01v8_hvt ad=0.1525 pd=1.305 as=0.135 ps=1.27 w=1 l=0.15
X4 Y B1 a_109_297# VPB sky130_fd_pr__pfet_01v8_hvt ad=0.27 pd=2.54 as=0.1625 ps=1.325 w=1 l=0.15
X5 a_109_297# A1 VPWR VPB sky130_fd_pr__pfet_01v8_hvt ad=0.1625 pd=1.325 as=0.1525 ps=1.305 w=1 l=0.15
X6 a_109_297# A3 VPWR VPB sky130_fd_pr__pfet_01v8_hvt ad=0.135 pd=1.27 as=0.26 ps=2.52 w=1 l=0.15
X7 a_109_47# A3 VGND VNB sky130_fd_pr__nfet_01v8 ad=0.06825 pd=0.86 as=0.169 ps=1.82 w=0.65 l=0.15
.ends

.subckt sky130_fd_sc_hd__a221oi_1 VGND VPWR VPB VNB Y B1 C1 A1 A2 B2
X0 a_465_47# A1 Y VNB sky130_fd_pr__nfet_01v8 ad=0.09912 pd=0.955 as=0.169 ps=1.82 w=0.65 l=0.15
X1 a_109_297# B1 a_193_297# VPB sky130_fd_pr__pfet_01v8_hvt ad=0.26 pd=2.52 as=0.135 ps=1.27 w=1 l=0.15
X2 a_193_297# B2 a_109_297# VPB sky130_fd_pr__pfet_01v8_hvt ad=0.135 pd=1.27 as=0.135 ps=1.27 w=1 l=0.15
X3 a_204_47# B2 VGND VNB sky130_fd_pr__nfet_01v8 ad=0.06988 pd=0.865 as=0.10563 ps=0.975 w=0.65 l=0.15
X4 VGND A2 a_465_47# VNB sky130_fd_pr__nfet_01v8 ad=0.19825 pd=1.91 as=0.09912 ps=0.955 w=0.65 l=0.15
X5 a_193_297# A1 VPWR VPB sky130_fd_pr__pfet_01v8_hvt ad=0.1525 pd=1.305 as=0.26 ps=2.52 w=1 l=0.15
X6 Y B1 a_204_47# VNB sky130_fd_pr__nfet_01v8 ad=0.169 pd=1.82 as=0.06988 ps=0.865 w=0.65 l=0.15
X7 VPWR A2 a_193_297# VPB sky130_fd_pr__pfet_01v8_hvt ad=0.305 pd=2.61 as=0.1525 ps=1.305 w=1 l=0.15
X8 a_109_297# C1 Y VPB sky130_fd_pr__pfet_01v8_hvt ad=0.135 pd=1.27 as=0.26 ps=2.52 w=1 l=0.15
X9 VGND C1 Y VNB sky130_fd_pr__nfet_01v8 ad=0.10563 pd=0.975 as=0.169 ps=1.82 w=0.65 l=0.15
.ends

.subckt sky130_fd_sc_hd__a21o_1 VPWR VGND VPB VNB A2 A1 B1 X
X0 a_81_21# B1 VGND VNB sky130_fd_pr__nfet_01v8 ad=0.08937 pd=0.925 as=0.25675 ps=1.44 w=0.65 l=0.15
X1 a_299_297# B1 a_81_21# VPB sky130_fd_pr__pfet_01v8_hvt ad=0.1375 pd=1.275 as=0.26 ps=2.52 w=1 l=0.15
X2 VPWR a_81_21# X VPB sky130_fd_pr__pfet_01v8_hvt ad=0.26 pd=2.52 as=0.26 ps=2.52 w=1 l=0.15
X3 VPWR A1 a_299_297# VPB sky130_fd_pr__pfet_01v8_hvt ad=0.14 pd=1.28 as=0.1375 ps=1.275 w=1 l=0.15
X4 VGND a_81_21# X VNB sky130_fd_pr__nfet_01v8 ad=0.25675 pd=1.44 as=0.169 ps=1.82 w=0.65 l=0.15
X5 VGND A2 a_384_47# VNB sky130_fd_pr__nfet_01v8 ad=0.17225 pd=1.83 as=0.091 ps=0.93 w=0.65 l=0.15
X6 a_299_297# A2 VPWR VPB sky130_fd_pr__pfet_01v8_hvt ad=0.265 pd=2.53 as=0.14 ps=1.28 w=1 l=0.15
X7 a_384_47# A1 a_81_21# VNB sky130_fd_pr__nfet_01v8 ad=0.091 pd=0.93 as=0.08937 ps=0.925 w=0.65 l=0.15
.ends

.subckt sky130_fd_sc_hd__or4_1 VPWR VGND VPB VNB B D C A X
X0 a_27_297# B VGND VNB sky130_fd_pr__nfet_01v8 ad=0.0567 pd=0.69 as=0.0567 ps=0.69 w=0.42 l=0.15
X1 a_27_297# D VGND VNB sky130_fd_pr__nfet_01v8 ad=0.0693 pd=0.75 as=0.1092 ps=1.36 w=0.42 l=0.15
X2 a_277_297# B a_205_297# VPB sky130_fd_pr__pfet_01v8_hvt ad=0.0693 pd=0.75 as=0.0441 ps=0.63 w=0.42 l=0.15
X3 VPWR A a_277_297# VPB sky130_fd_pr__pfet_01v8_hvt ad=0.14825 pd=1.34 as=0.0693 ps=0.75 w=0.42 l=0.15
X4 X a_27_297# VGND VNB sky130_fd_pr__nfet_01v8 ad=0.1755 pd=1.84 as=0.10187 ps=0.99 w=0.65 l=0.15
X5 a_205_297# C a_109_297# VPB sky130_fd_pr__pfet_01v8_hvt ad=0.0441 pd=0.63 as=0.0693 ps=0.75 w=0.42 l=0.15
X6 X a_27_297# VPWR VPB sky130_fd_pr__pfet_01v8_hvt ad=0.27 pd=2.54 as=0.14825 ps=1.34 w=1 l=0.15
X7 VGND C a_27_297# VNB sky130_fd_pr__nfet_01v8 ad=0.0567 pd=0.69 as=0.0693 ps=0.75 w=0.42 l=0.15
X8 a_109_297# D a_27_297# VPB sky130_fd_pr__pfet_01v8_hvt ad=0.0693 pd=0.75 as=0.1092 ps=1.36 w=0.42 l=0.15
X9 VGND A a_27_297# VNB sky130_fd_pr__nfet_01v8 ad=0.10187 pd=0.99 as=0.0567 ps=0.69 w=0.42 l=0.15
.ends

.subckt sky130_fd_sc_hd__o2bb2ai_1 VPB VNB VGND VPWR B1 B2 Y A2_N A1_N
X0 VPWR A2_N a_112_297# VPB sky130_fd_pr__pfet_01v8_hvt ad=0.42 pd=1.84 as=0.135 ps=1.27 w=1 l=0.15
X1 Y a_112_297# VPWR VPB sky130_fd_pr__pfet_01v8_hvt ad=0.135 pd=1.27 as=0.42 ps=1.84 w=1 l=0.15
X2 VGND B2 a_394_47# VNB sky130_fd_pr__nfet_01v8 ad=0.08775 pd=0.92 as=0.08775 ps=0.92 w=0.65 l=0.15
X3 a_112_297# A2_N a_112_47# VNB sky130_fd_pr__nfet_01v8 ad=0.2405 pd=2.04 as=0.06825 ps=0.86 w=0.65 l=0.15
X4 a_112_47# A1_N VGND VNB sky130_fd_pr__nfet_01v8 ad=0.06825 pd=0.86 as=0.17875 ps=1.85 w=0.65 l=0.15
X5 a_112_297# A1_N VPWR VPB sky130_fd_pr__pfet_01v8_hvt ad=0.135 pd=1.27 as=0.275 ps=2.55 w=1 l=0.15
X6 VPWR B1 a_478_297# VPB sky130_fd_pr__pfet_01v8_hvt ad=0.275 pd=2.55 as=0.135 ps=1.27 w=1 l=0.15
X7 a_394_47# a_112_297# Y VNB sky130_fd_pr__nfet_01v8 ad=0.08775 pd=0.92 as=0.169 ps=1.82 w=0.65 l=0.15
X8 a_394_47# B1 VGND VNB sky130_fd_pr__nfet_01v8 ad=0.169 pd=1.82 as=0.08775 ps=0.92 w=0.65 l=0.15
X9 a_478_297# B2 Y VPB sky130_fd_pr__pfet_01v8_hvt ad=0.135 pd=1.27 as=0.135 ps=1.27 w=1 l=0.15
.ends

.subckt sky130_fd_sc_hd__and3b_1 A_N B X C VGND VPWR VPB VNB
X0 a_109_93# A_N VGND VNB sky130_fd_pr__nfet_01v8 ad=0.10785 pd=1.36 as=0.1092 ps=1.36 w=0.42 l=0.15
X1 X a_209_311# VPWR VPB sky130_fd_pr__pfet_01v8_hvt ad=0.26 pd=2.52 as=0.14222 ps=1.335 w=1 l=0.15
X2 a_109_93# A_N VPWR VPB sky130_fd_pr__pfet_01v8_hvt ad=0.1087 pd=1.36 as=0.1092 ps=1.36 w=0.42 l=0.15
X3 a_296_53# a_109_93# a_209_311# VNB sky130_fd_pr__nfet_01v8 ad=0.0441 pd=0.63 as=0.10783 ps=1.36 w=0.42 l=0.15
X4 VPWR C a_209_311# VPB sky130_fd_pr__pfet_01v8_hvt ad=0.14222 pd=1.335 as=0.07438 ps=0.815 w=0.42 l=0.15
X5 a_368_53# B a_296_53# VNB sky130_fd_pr__nfet_01v8 ad=0.05355 pd=0.675 as=0.0441 ps=0.63 w=0.42 l=0.15
X6 X a_209_311# VGND VNB sky130_fd_pr__nfet_01v8 ad=0.169 pd=1.82 as=0.12228 ps=1.08 w=0.65 l=0.15
X7 a_209_311# B VPWR VPB sky130_fd_pr__pfet_01v8_hvt ad=0.07438 pd=0.815 as=0.0567 ps=0.69 w=0.42 l=0.15
X8 VPWR a_109_93# a_209_311# VPB sky130_fd_pr__pfet_01v8_hvt ad=0.0567 pd=0.69 as=0.1085 ps=1.36 w=0.42 l=0.15
X9 VGND C a_368_53# VNB sky130_fd_pr__nfet_01v8 ad=0.12228 pd=1.08 as=0.05355 ps=0.675 w=0.42 l=0.15
.ends

.subckt sky130_fd_sc_hd__clkbuf_16 VNB VPB VGND VPWR A X
X0 VPWR A a_110_47# VPB sky130_fd_pr__pfet_01v8_hvt ad=0.14 pd=1.28 as=0.14 ps=1.28 w=1 l=0.15
X1 VPWR a_110_47# X VPB sky130_fd_pr__pfet_01v8_hvt ad=0.14 pd=1.28 as=0.14 ps=1.28 w=1 l=0.15
X2 X a_110_47# VPWR VPB sky130_fd_pr__pfet_01v8_hvt ad=0.14 pd=1.28 as=0.14 ps=1.28 w=1 l=0.15
X3 X a_110_47# VPWR VPB sky130_fd_pr__pfet_01v8_hvt ad=0.14 pd=1.28 as=0.14 ps=1.28 w=1 l=0.15
X4 VPWR a_110_47# X VPB sky130_fd_pr__pfet_01v8_hvt ad=0.14 pd=1.28 as=0.14 ps=1.28 w=1 l=0.15
X5 VPWR a_110_47# X VPB sky130_fd_pr__pfet_01v8_hvt ad=0.265 pd=2.53 as=0.14 ps=1.28 w=1 l=0.15
X6 a_110_47# A VPWR VPB sky130_fd_pr__pfet_01v8_hvt ad=0.14 pd=1.28 as=0.265 ps=2.53 w=1 l=0.15
X7 a_110_47# A VGND VNB sky130_fd_pr__nfet_01v8 ad=0.0588 pd=0.7 as=0.0588 ps=0.7 w=0.42 l=0.15
X8 VGND a_110_47# X VNB sky130_fd_pr__nfet_01v8 ad=0.0588 pd=0.7 as=0.0588 ps=0.7 w=0.42 l=0.15
X9 X a_110_47# VGND VNB sky130_fd_pr__nfet_01v8 ad=0.0588 pd=0.7 as=0.0588 ps=0.7 w=0.42 l=0.15
X10 VGND a_110_47# X VNB sky130_fd_pr__nfet_01v8 ad=0.0588 pd=0.7 as=0.0588 ps=0.7 w=0.42 l=0.15
X11 a_110_47# A VPWR VPB sky130_fd_pr__pfet_01v8_hvt ad=0.14 pd=1.28 as=0.14 ps=1.28 w=1 l=0.15
X12 VGND A a_110_47# VNB sky130_fd_pr__nfet_01v8 ad=0.0588 pd=0.7 as=0.0588 ps=0.7 w=0.42 l=0.15
X13 VGND a_110_47# X VNB sky130_fd_pr__nfet_01v8 ad=0.05775 pd=0.695 as=0.0588 ps=0.7 w=0.42 l=0.15
X14 VPWR a_110_47# X VPB sky130_fd_pr__pfet_01v8_hvt ad=0.14 pd=1.28 as=0.14 ps=1.28 w=1 l=0.15
X15 X a_110_47# VPWR VPB sky130_fd_pr__pfet_01v8_hvt ad=0.14 pd=1.28 as=0.14 ps=1.28 w=1 l=0.15
X16 VGND A a_110_47# VNB sky130_fd_pr__nfet_01v8 ad=0.0588 pd=0.7 as=0.0588 ps=0.7 w=0.42 l=0.15
X17 VGND a_110_47# X VNB sky130_fd_pr__nfet_01v8 ad=0.1113 pd=1.37 as=0.0588 ps=0.7 w=0.42 l=0.15
X18 VPWR a_110_47# X VPB sky130_fd_pr__pfet_01v8_hvt ad=0.1375 pd=1.275 as=0.14 ps=1.28 w=1 l=0.15
X19 VGND a_110_47# X VNB sky130_fd_pr__nfet_01v8 ad=0.0588 pd=0.7 as=0.0588 ps=0.7 w=0.42 l=0.15
X20 X a_110_47# VPWR VPB sky130_fd_pr__pfet_01v8_hvt ad=0.14 pd=1.28 as=0.1375 ps=1.275 w=1 l=0.15
X21 a_110_47# A VGND VNB sky130_fd_pr__nfet_01v8 ad=0.0588 pd=0.7 as=0.1113 ps=1.37 w=0.42 l=0.15
X22 VPWR A a_110_47# VPB sky130_fd_pr__pfet_01v8_hvt ad=0.14 pd=1.28 as=0.14 ps=1.28 w=1 l=0.15
X23 VPWR a_110_47# X VPB sky130_fd_pr__pfet_01v8_hvt ad=0.14 pd=1.28 as=0.14 ps=1.28 w=1 l=0.15
X24 VPWR a_110_47# X VPB sky130_fd_pr__pfet_01v8_hvt ad=0.14 pd=1.28 as=0.14 ps=1.28 w=1 l=0.15
X25 VGND a_110_47# X VNB sky130_fd_pr__nfet_01v8 ad=0.0588 pd=0.7 as=0.0588 ps=0.7 w=0.42 l=0.15
X26 X a_110_47# VPWR VPB sky130_fd_pr__pfet_01v8_hvt ad=0.14 pd=1.28 as=0.14 ps=1.28 w=1 l=0.15
X27 VGND a_110_47# X VNB sky130_fd_pr__nfet_01v8 ad=0.0588 pd=0.7 as=0.0588 ps=0.7 w=0.42 l=0.15
X28 VGND a_110_47# X VNB sky130_fd_pr__nfet_01v8 ad=0.0588 pd=0.7 as=0.0588 ps=0.7 w=0.42 l=0.15
X29 X a_110_47# VGND VNB sky130_fd_pr__nfet_01v8 ad=0.0588 pd=0.7 as=0.0588 ps=0.7 w=0.42 l=0.15
X30 X a_110_47# VPWR VPB sky130_fd_pr__pfet_01v8_hvt ad=0.14 pd=1.28 as=0.14 ps=1.28 w=1 l=0.15
X31 X a_110_47# VPWR VPB sky130_fd_pr__pfet_01v8_hvt ad=0.14 pd=1.28 as=0.14 ps=1.28 w=1 l=0.15
X32 X a_110_47# VGND VNB sky130_fd_pr__nfet_01v8 ad=0.0588 pd=0.7 as=0.0588 ps=0.7 w=0.42 l=0.15
X33 VPWR a_110_47# X VPB sky130_fd_pr__pfet_01v8_hvt ad=0.14 pd=1.28 as=0.14 ps=1.28 w=1 l=0.15
X34 X a_110_47# VPWR VPB sky130_fd_pr__pfet_01v8_hvt ad=0.14 pd=1.28 as=0.14 ps=1.28 w=1 l=0.15
X35 X a_110_47# VGND VNB sky130_fd_pr__nfet_01v8 ad=0.0588 pd=0.7 as=0.0588 ps=0.7 w=0.42 l=0.15
X36 X a_110_47# VGND VNB sky130_fd_pr__nfet_01v8 ad=0.0588 pd=0.7 as=0.0588 ps=0.7 w=0.42 l=0.15
X37 X a_110_47# VGND VNB sky130_fd_pr__nfet_01v8 ad=0.0588 pd=0.7 as=0.0588 ps=0.7 w=0.42 l=0.15
X38 X a_110_47# VGND VNB sky130_fd_pr__nfet_01v8 ad=0.0588 pd=0.7 as=0.0588 ps=0.7 w=0.42 l=0.15
X39 X a_110_47# VGND VNB sky130_fd_pr__nfet_01v8 ad=0.0588 pd=0.7 as=0.05775 ps=0.695 w=0.42 l=0.15
.ends

.subckt sky130_fd_sc_hd__a311oi_1 VPB VNB Y C1 B1 A1 A2 A3 VPWR VGND
X0 Y A1 a_194_47# VNB sky130_fd_pr__nfet_01v8 ad=0.11537 pd=1.005 as=0.091 ps=0.93 w=0.65 l=0.15
X1 a_194_47# A2 a_109_47# VNB sky130_fd_pr__nfet_01v8 ad=0.091 pd=0.93 as=0.08937 ps=0.925 w=0.65 l=0.15
X2 Y C1 a_376_297# VPB sky130_fd_pr__pfet_01v8_hvt ad=0.26 pd=2.52 as=0.1725 ps=1.345 w=1 l=0.15
X3 VPWR A2 a_109_297# VPB sky130_fd_pr__pfet_01v8_hvt ad=0.14 pd=1.28 as=0.1375 ps=1.275 w=1 l=0.15
X4 Y C1 VGND VNB sky130_fd_pr__nfet_01v8 ad=0.169 pd=1.82 as=0.11213 ps=0.995 w=0.65 l=0.15
X5 VGND B1 Y VNB sky130_fd_pr__nfet_01v8 ad=0.11213 pd=0.995 as=0.11537 ps=1.005 w=0.65 l=0.15
X6 a_109_297# A1 VPWR VPB sky130_fd_pr__pfet_01v8_hvt ad=0.165 pd=1.33 as=0.14 ps=1.28 w=1 l=0.15
X7 a_376_297# B1 a_109_297# VPB sky130_fd_pr__pfet_01v8_hvt ad=0.1725 pd=1.345 as=0.165 ps=1.33 w=1 l=0.15
X8 a_109_297# A3 VPWR VPB sky130_fd_pr__pfet_01v8_hvt ad=0.1375 pd=1.275 as=0.26 ps=2.52 w=1 l=0.15
X9 a_109_47# A3 VGND VNB sky130_fd_pr__nfet_01v8 ad=0.08937 pd=0.925 as=0.169 ps=1.82 w=0.65 l=0.15
.ends

.subckt sky130_fd_sc_hd__xor3_1 VNB VPB VGND VPWR X C B A
X0 a_112_21# C a_404_49# VNB sky130_fd_pr__nfet_01v8 ad=0.128 pd=1.04 as=0.1728 ps=1.82 w=0.64 l=0.15
X1 a_1198_49# a_931_365# VGND VNB sky130_fd_pr__nfet_01v8 ad=0.1824 pd=1.85 as=0.0864 ps=0.91 w=0.64 l=0.15
X2 a_386_325# B a_1198_49# VNB sky130_fd_pr__nfet_01v8 ad=0.14083 pd=1.1 as=0.19265 ps=1.285 w=0.64 l=0.15
X3 a_404_49# a_266_93# a_112_21# VPB sky130_fd_pr__pfet_01v8_hvt ad=0.441 pd=2.73 as=0.1596 ps=1.22 w=0.84 l=0.15
X4 a_931_365# a_827_297# a_404_49# VPB sky130_fd_pr__pfet_01v8_hvt ad=0.1715 pd=1.355 as=0.1458 ps=1.205 w=0.84 l=0.15
X5 VPWR a_112_21# X VPB sky130_fd_pr__pfet_01v8_hvt ad=0.2115 pd=1.45 as=0.28 ps=2.56 w=1 l=0.15
X6 a_827_297# B VGND VNB sky130_fd_pr__nfet_01v8 ad=0.1653 pd=1.82 as=0.195 ps=1.9 w=0.65 l=0.15
X7 a_1198_49# a_827_297# a_404_49# VNB sky130_fd_pr__nfet_01v8 ad=0.19265 pd=1.285 as=0.18365 ps=1.25 w=0.42 l=0.15
X8 VGND A a_931_365# VNB sky130_fd_pr__nfet_01v8 ad=0.0864 pd=0.91 as=0.11 ps=0.99 w=0.64 l=0.15
X9 a_112_21# C a_386_325# VPB sky130_fd_pr__pfet_01v8_hvt ad=0.1596 pd=1.22 as=0.2688 ps=2.32 w=0.84 l=0.15
X10 a_1198_49# a_827_297# a_386_325# VPB sky130_fd_pr__pfet_01v8_hvt ad=0.246 pd=1.525 as=0.2452 ps=1.45 w=0.64 l=0.15
X11 a_266_93# C VPWR VPB sky130_fd_pr__pfet_01v8_hvt ad=0.1792 pd=1.84 as=0.2115 ps=1.45 w=0.64 l=0.15
X12 a_1198_49# a_931_365# VPWR VPB sky130_fd_pr__pfet_01v8_hvt ad=0.285 pd=2.57 as=0.135 ps=1.27 w=1 l=0.15
X13 a_931_365# a_827_297# a_386_325# VNB sky130_fd_pr__nfet_01v8 ad=0.11 pd=0.99 as=0.14083 ps=1.1 w=0.6 l=0.15
X14 VPWR A a_931_365# VPB sky130_fd_pr__pfet_01v8_hvt ad=0.135 pd=1.27 as=0.1715 ps=1.355 w=1 l=0.15
X15 a_827_297# B VPWR VPB sky130_fd_pr__pfet_01v8_hvt ad=0.2526 pd=2.52 as=0.26 ps=2.52 w=1 l=0.15
X16 VGND a_112_21# X VNB sky130_fd_pr__nfet_01v8 ad=0.14412 pd=1.12 as=0.169 ps=1.82 w=0.65 l=0.15
X17 a_386_325# B a_931_365# VPB sky130_fd_pr__pfet_01v8_hvt ad=0.2452 pd=1.45 as=0.3536 ps=2.53 w=0.84 l=0.15
X18 a_266_93# C VGND VNB sky130_fd_pr__nfet_01v8 ad=0.1764 pd=1.68 as=0.14412 ps=1.12 w=0.42 l=0.15
X19 a_404_49# B a_931_365# VNB sky130_fd_pr__nfet_01v8 ad=0.18365 pd=1.25 as=0.1628 ps=1.8 w=0.64 l=0.15
X20 a_386_325# a_266_93# a_112_21# VNB sky130_fd_pr__nfet_01v8 ad=0.3168 pd=2.27 as=0.128 ps=1.04 w=0.64 l=0.15
X21 a_404_49# B a_1198_49# VPB sky130_fd_pr__pfet_01v8_hvt ad=0.1458 pd=1.205 as=0.246 ps=1.525 w=0.64 l=0.15
.ends

.subckt sky130_fd_sc_hd__a31o_1 VPB VNB X A3 A2 A1 B1 VGND VPWR
X0 VPWR a_80_21# X VPB sky130_fd_pr__pfet_01v8_hvt ad=0.1725 pd=1.345 as=0.265 ps=2.53 w=1 l=0.15
X1 a_209_297# A3 VPWR VPB sky130_fd_pr__pfet_01v8_hvt ad=0.16 pd=1.32 as=0.1725 ps=1.345 w=1 l=0.15
X2 a_303_47# A2 a_209_47# VNB sky130_fd_pr__nfet_01v8 ad=0.10725 pd=0.98 as=0.104 ps=0.97 w=0.65 l=0.15
X3 a_209_47# A3 VGND VNB sky130_fd_pr__nfet_01v8 ad=0.104 pd=0.97 as=0.11213 ps=0.995 w=0.65 l=0.15
X4 VGND a_80_21# X VNB sky130_fd_pr__nfet_01v8 ad=0.11213 pd=0.995 as=0.17225 ps=1.83 w=0.65 l=0.15
X5 VGND B1 a_80_21# VNB sky130_fd_pr__nfet_01v8 ad=0.208 pd=1.94 as=0.10725 ps=0.98 w=0.65 l=0.15
X6 a_80_21# A1 a_303_47# VNB sky130_fd_pr__nfet_01v8 ad=0.10725 pd=0.98 as=0.10725 ps=0.98 w=0.65 l=0.15
X7 VPWR A2 a_209_297# VPB sky130_fd_pr__pfet_01v8_hvt ad=0.165 pd=1.33 as=0.16 ps=1.32 w=1 l=0.15
X8 a_80_21# B1 a_209_297# VPB sky130_fd_pr__pfet_01v8_hvt ad=0.32 pd=2.64 as=0.165 ps=1.33 w=1 l=0.15
X9 a_209_297# A1 VPWR VPB sky130_fd_pr__pfet_01v8_hvt ad=0.165 pd=1.33 as=0.165 ps=1.33 w=1 l=0.15
.ends

.subckt sky130_fd_sc_hd__clkbuf_1 VGND VPWR X A VPB VNB
X0 VPWR a_75_212# X VPB sky130_fd_pr__pfet_01v8_hvt ad=0.11455 pd=1.08 as=0.2054 ps=2.1 w=0.79 l=0.15
X1 a_75_212# A VGND VNB sky130_fd_pr__nfet_01v8 ad=0.1352 pd=1.56 as=0.0754 ps=0.81 w=0.52 l=0.15
X2 a_75_212# A VPWR VPB sky130_fd_pr__pfet_01v8_hvt ad=0.2054 pd=2.1 as=0.11455 ps=1.08 w=0.79 l=0.15
X3 VGND a_75_212# X VNB sky130_fd_pr__nfet_01v8 ad=0.0754 pd=0.81 as=0.1352 ps=1.56 w=0.52 l=0.15
.ends

.subckt sky130_fd_sc_hd__nand4_1 VPB VNB VPWR VGND A C D Y B
X0 Y B VPWR VPB sky130_fd_pr__pfet_01v8_hvt ad=0.165 pd=1.33 as=0.135 ps=1.27 w=1 l=0.15
X1 VPWR A Y VPB sky130_fd_pr__pfet_01v8_hvt ad=0.3 pd=2.6 as=0.165 ps=1.33 w=1 l=0.15
X2 VPWR C Y VPB sky130_fd_pr__pfet_01v8_hvt ad=0.135 pd=1.27 as=0.135 ps=1.27 w=1 l=0.15
X3 a_193_47# C a_109_47# VNB sky130_fd_pr__nfet_01v8 ad=0.08775 pd=0.92 as=0.08775 ps=0.92 w=0.65 l=0.15
X4 Y A a_277_47# VNB sky130_fd_pr__nfet_01v8 ad=0.195 pd=1.9 as=0.10725 ps=0.98 w=0.65 l=0.15
X5 a_277_47# B a_193_47# VNB sky130_fd_pr__nfet_01v8 ad=0.10725 pd=0.98 as=0.08775 ps=0.92 w=0.65 l=0.15
X6 Y D VPWR VPB sky130_fd_pr__pfet_01v8_hvt ad=0.135 pd=1.27 as=0.26 ps=2.52 w=1 l=0.15
X7 a_109_47# D VGND VNB sky130_fd_pr__nfet_01v8 ad=0.08775 pd=0.92 as=0.169 ps=1.82 w=0.65 l=0.15
.ends

.subckt sky130_fd_sc_hd__o221ai_1 VPB VNB VGND VPWR A1 A2 Y B2 C1 B1
X0 a_109_47# B1 a_213_123# VNB sky130_fd_pr__nfet_01v8 ad=0.08775 pd=0.92 as=0.1652 ps=1.82 w=0.65 l=0.15
X1 Y B2 a_295_297# VPB sky130_fd_pr__pfet_01v8_hvt ad=0.225 pd=1.45 as=0.12 ps=1.24 w=1 l=0.15
X2 VPWR A1 a_493_297# VPB sky130_fd_pr__pfet_01v8_hvt ad=0.26 pd=2.52 as=0.105 ps=1.21 w=1 l=0.15
X3 a_213_123# B2 a_109_47# VNB sky130_fd_pr__nfet_01v8 ad=0.117 pd=1.01 as=0.08775 ps=0.92 w=0.65 l=0.15
X4 a_295_297# B1 VPWR VPB sky130_fd_pr__pfet_01v8_hvt ad=0.12 pd=1.24 as=0.38 ps=1.76 w=1 l=0.15
X5 a_493_297# A2 Y VPB sky130_fd_pr__pfet_01v8_hvt ad=0.105 pd=1.21 as=0.225 ps=1.45 w=1 l=0.15
X6 VPWR C1 Y VPB sky130_fd_pr__pfet_01v8_hvt ad=0.38 pd=1.76 as=0.28 ps=2.56 w=1 l=0.15
X7 VGND A2 a_213_123# VNB sky130_fd_pr__nfet_01v8 ad=0.08775 pd=0.92 as=0.117 ps=1.01 w=0.65 l=0.15
X8 a_213_123# A1 VGND VNB sky130_fd_pr__nfet_01v8 ad=0.169 pd=1.82 as=0.08775 ps=0.92 w=0.65 l=0.15
X9 a_109_47# C1 Y VNB sky130_fd_pr__nfet_01v8 ad=0.1654 pd=1.82 as=0.169 ps=1.82 w=0.65 l=0.15
.ends

.subckt sky130_fd_sc_hd__or2_0 VNB VPB VGND VPWR B A X
X0 VGND A a_68_355# VNB sky130_fd_pr__nfet_01v8 ad=0.07035 pd=0.755 as=0.0567 ps=0.69 w=0.42 l=0.15
X1 a_150_355# B a_68_355# VPB sky130_fd_pr__pfet_01v8_hvt ad=0.0441 pd=0.63 as=0.1092 ps=1.36 w=0.42 l=0.15
X2 a_68_355# B VGND VNB sky130_fd_pr__nfet_01v8 ad=0.0567 pd=0.69 as=0.1092 ps=1.36 w=0.42 l=0.15
X3 X a_68_355# VGND VNB sky130_fd_pr__nfet_01v8 ad=0.1092 pd=1.36 as=0.07035 ps=0.755 w=0.42 l=0.15
X4 VPWR A a_150_355# VPB sky130_fd_pr__pfet_01v8_hvt ad=0.09895 pd=0.975 as=0.0441 ps=0.63 w=0.42 l=0.15
X5 X a_68_355# VPWR VPB sky130_fd_pr__pfet_01v8_hvt ad=0.2176 pd=1.96 as=0.09895 ps=0.975 w=0.64 l=0.15
.ends

.subckt sky130_fd_sc_hd__clkinv_2 VNB VPB VPWR VGND A Y
X0 Y A VGND VNB sky130_fd_pr__nfet_01v8 ad=0.0588 pd=0.7 as=0.1113 ps=1.37 w=0.42 l=0.15
X1 Y A VPWR VPB sky130_fd_pr__pfet_01v8_hvt ad=0.14 pd=1.28 as=0.14 ps=1.28 w=1 l=0.15
X2 VPWR A Y VPB sky130_fd_pr__pfet_01v8_hvt ad=0.14 pd=1.28 as=0.265 ps=2.53 w=1 l=0.15
X3 VGND A Y VNB sky130_fd_pr__nfet_01v8 ad=0.1092 pd=1.36 as=0.0588 ps=0.7 w=0.42 l=0.15
X4 VPWR A Y VPB sky130_fd_pr__pfet_01v8_hvt ad=0.265 pd=2.53 as=0.14 ps=1.28 w=1 l=0.15
.ends

.subckt sky130_fd_sc_hd__inv_8 VNB VPB VGND VPWR Y A
X0 VPWR A Y VPB sky130_fd_pr__pfet_01v8_hvt ad=0.135 pd=1.27 as=0.135 ps=1.27 w=1 l=0.15
X1 Y A VPWR VPB sky130_fd_pr__pfet_01v8_hvt ad=0.135 pd=1.27 as=0.135 ps=1.27 w=1 l=0.15
X2 Y A VGND VNB sky130_fd_pr__nfet_01v8 ad=0.08775 pd=0.92 as=0.08775 ps=0.92 w=0.65 l=0.15
X3 Y A VGND VNB sky130_fd_pr__nfet_01v8 ad=0.08775 pd=0.92 as=0.08775 ps=0.92 w=0.65 l=0.15
X4 VPWR A Y VPB sky130_fd_pr__pfet_01v8_hvt ad=0.135 pd=1.27 as=0.135 ps=1.27 w=1 l=0.15
X5 Y A VPWR VPB sky130_fd_pr__pfet_01v8_hvt ad=0.135 pd=1.27 as=0.26 ps=2.52 w=1 l=0.15
X6 Y A VGND VNB sky130_fd_pr__nfet_01v8 ad=0.08775 pd=0.92 as=0.169 ps=1.82 w=0.65 l=0.15
X7 VPWR A Y VPB sky130_fd_pr__pfet_01v8_hvt ad=0.26 pd=2.52 as=0.135 ps=1.27 w=1 l=0.15
X8 Y A VGND VNB sky130_fd_pr__nfet_01v8 ad=0.08775 pd=0.92 as=0.08775 ps=0.92 w=0.65 l=0.15
X9 Y A VPWR VPB sky130_fd_pr__pfet_01v8_hvt ad=0.135 pd=1.27 as=0.135 ps=1.27 w=1 l=0.15
X10 VPWR A Y VPB sky130_fd_pr__pfet_01v8_hvt ad=0.135 pd=1.27 as=0.135 ps=1.27 w=1 l=0.15
X11 VGND A Y VNB sky130_fd_pr__nfet_01v8 ad=0.08775 pd=0.92 as=0.08775 ps=0.92 w=0.65 l=0.15
X12 VGND A Y VNB sky130_fd_pr__nfet_01v8 ad=0.08775 pd=0.92 as=0.08775 ps=0.92 w=0.65 l=0.15
X13 VGND A Y VNB sky130_fd_pr__nfet_01v8 ad=0.08775 pd=0.92 as=0.08775 ps=0.92 w=0.65 l=0.15
X14 Y A VPWR VPB sky130_fd_pr__pfet_01v8_hvt ad=0.135 pd=1.27 as=0.135 ps=1.27 w=1 l=0.15
X15 VGND A Y VNB sky130_fd_pr__nfet_01v8 ad=0.169 pd=1.82 as=0.08775 ps=0.92 w=0.65 l=0.15
.ends

.subckt sky130_fd_sc_hd__o21a_1 VPB VNB VGND VPWR A1 A2 B1 X
X0 VPWR A1 a_382_297# VPB sky130_fd_pr__pfet_01v8_hvt ad=0.26 pd=2.52 as=0.1525 ps=1.305 w=1 l=0.15
X1 a_297_47# B1 a_79_21# VNB sky130_fd_pr__nfet_01v8 ad=0.10075 pd=0.96 as=0.169 ps=1.82 w=0.65 l=0.15
X2 a_297_47# A1 VGND VNB sky130_fd_pr__nfet_01v8 ad=0.169 pd=1.82 as=0.08775 ps=0.92 w=0.65 l=0.15
X3 VGND A2 a_297_47# VNB sky130_fd_pr__nfet_01v8 ad=0.08775 pd=0.92 as=0.10075 ps=0.96 w=0.65 l=0.15
X4 VPWR a_79_21# X VPB sky130_fd_pr__pfet_01v8_hvt ad=0.3275 pd=1.655 as=0.28 ps=2.56 w=1 l=0.15
X5 a_79_21# B1 VPWR VPB sky130_fd_pr__pfet_01v8_hvt ad=0.195 pd=1.39 as=0.3275 ps=1.655 w=1 l=0.15
X6 a_382_297# A2 a_79_21# VPB sky130_fd_pr__pfet_01v8_hvt ad=0.1525 pd=1.305 as=0.195 ps=1.39 w=1 l=0.15
X7 VGND a_79_21# X VNB sky130_fd_pr__nfet_01v8 ad=0.169 pd=1.82 as=0.169 ps=1.82 w=0.65 l=0.15
.ends

.subckt sky130_fd_sc_hd__nand2b_1 VPB VNB VGND VPWR A_N B Y
X0 VGND A_N a_27_93# VNB sky130_fd_pr__nfet_01v8 ad=0.10025 pd=0.985 as=0.1092 ps=1.36 w=0.42 l=0.15
X1 Y a_27_93# a_206_47# VNB sky130_fd_pr__nfet_01v8 ad=0.169 pd=1.82 as=0.08775 ps=0.92 w=0.65 l=0.15
X2 a_206_47# B VGND VNB sky130_fd_pr__nfet_01v8 ad=0.08775 pd=0.92 as=0.10025 ps=0.985 w=0.65 l=0.15
X3 VPWR a_27_93# Y VPB sky130_fd_pr__pfet_01v8_hvt ad=0.265 pd=2.53 as=0.135 ps=1.27 w=1 l=0.15
X4 Y B VPWR VPB sky130_fd_pr__pfet_01v8_hvt ad=0.135 pd=1.27 as=0.14575 ps=1.335 w=1 l=0.15
X5 VPWR A_N a_27_93# VPB sky130_fd_pr__pfet_01v8_hvt ad=0.14575 pd=1.335 as=0.1092 ps=1.36 w=0.42 l=0.15
.ends

.subckt sky130_fd_sc_hd__inv_4 VPB VNB VPWR VGND Y A
X0 VPWR A Y VPB sky130_fd_pr__pfet_01v8_hvt ad=0.26 pd=2.52 as=0.135 ps=1.27 w=1 l=0.15
X1 Y A VPWR VPB sky130_fd_pr__pfet_01v8_hvt ad=0.135 pd=1.27 as=0.135 ps=1.27 w=1 l=0.15
X2 Y A VGND VNB sky130_fd_pr__nfet_01v8 ad=0.08775 pd=0.92 as=0.169 ps=1.82 w=0.65 l=0.15
X3 VPWR A Y VPB sky130_fd_pr__pfet_01v8_hvt ad=0.135 pd=1.27 as=0.135 ps=1.27 w=1 l=0.15
X4 VGND A Y VNB sky130_fd_pr__nfet_01v8 ad=0.08775 pd=0.92 as=0.08775 ps=0.92 w=0.65 l=0.15
X5 Y A VPWR VPB sky130_fd_pr__pfet_01v8_hvt ad=0.135 pd=1.27 as=0.26 ps=2.52 w=1 l=0.15
X6 VGND A Y VNB sky130_fd_pr__nfet_01v8 ad=0.169 pd=1.82 as=0.08775 ps=0.92 w=0.65 l=0.15
X7 Y A VGND VNB sky130_fd_pr__nfet_01v8 ad=0.08775 pd=0.92 as=0.08775 ps=0.92 w=0.65 l=0.15
.ends

.subckt sky130_fd_sc_hd__o31a_1 X A1 A2 A3 B1 VPB VNB VGND VPWR
X0 a_103_199# B1 a_253_47# VNB sky130_fd_pr__nfet_01v8 ad=0.2015 pd=1.92 as=0.10725 ps=0.98 w=0.65 l=0.15
X1 VPWR a_103_199# X VPB sky130_fd_pr__pfet_01v8_hvt ad=0.195 pd=1.39 as=0.36 ps=2.72 w=1 l=0.15
X2 a_337_297# A2 a_253_297# VPB sky130_fd_pr__pfet_01v8_hvt ad=0.165 pd=1.33 as=0.135 ps=1.27 w=1 l=0.15
X3 a_103_199# A3 a_337_297# VPB sky130_fd_pr__pfet_01v8_hvt ad=0.2125 pd=1.425 as=0.165 ps=1.33 w=1 l=0.15
X4 a_253_297# A1 VPWR VPB sky130_fd_pr__pfet_01v8_hvt ad=0.135 pd=1.27 as=0.195 ps=1.39 w=1 l=0.15
X5 VPWR B1 a_103_199# VPB sky130_fd_pr__pfet_01v8_hvt ad=0.345 pd=2.69 as=0.2125 ps=1.425 w=1 l=0.15
X6 VGND a_103_199# X VNB sky130_fd_pr__nfet_01v8 ad=0.12675 pd=1.04 as=0.234 ps=2.02 w=0.65 l=0.15
X7 a_253_47# A1 VGND VNB sky130_fd_pr__nfet_01v8 ad=0.08775 pd=0.92 as=0.12675 ps=1.04 w=0.65 l=0.15
X8 a_253_47# A3 VGND VNB sky130_fd_pr__nfet_01v8 ad=0.10725 pd=0.98 as=0.10725 ps=0.98 w=0.65 l=0.15
X9 VGND A2 a_253_47# VNB sky130_fd_pr__nfet_01v8 ad=0.10725 pd=0.98 as=0.08775 ps=0.92 w=0.65 l=0.15
.ends

.subckt sky130_fd_sc_hd__a2bb2oi_1 VPB VNB VGND VPWR Y A2_N A1_N B2 B1
X0 a_109_47# A2_N a_109_297# VPB sky130_fd_pr__pfet_01v8_hvt ad=0.26 pd=2.52 as=0.105 ps=1.21 w=1 l=0.15
X1 a_397_297# B1 VPWR VPB sky130_fd_pr__pfet_01v8_hvt ad=0.26 pd=2.52 as=0.135 ps=1.27 w=1 l=0.15
X2 VPWR B2 a_397_297# VPB sky130_fd_pr__pfet_01v8_hvt ad=0.135 pd=1.27 as=0.135 ps=1.27 w=1 l=0.15
X3 VGND A2_N a_109_47# VNB sky130_fd_pr__nfet_01v8 ad=0.28275 pd=1.52 as=0.08775 ps=0.92 w=0.65 l=0.15
X4 a_397_297# a_109_47# Y VPB sky130_fd_pr__pfet_01v8_hvt ad=0.135 pd=1.27 as=0.34 ps=2.68 w=1 l=0.15
X5 a_481_47# B2 Y VNB sky130_fd_pr__nfet_01v8 ad=0.08775 pd=0.92 as=0.08775 ps=0.92 w=0.65 l=0.15
X6 Y a_109_47# VGND VNB sky130_fd_pr__nfet_01v8 ad=0.08775 pd=0.92 as=0.28275 ps=1.52 w=0.65 l=0.15
X7 VGND B1 a_481_47# VNB sky130_fd_pr__nfet_01v8 ad=0.169 pd=1.82 as=0.08775 ps=0.92 w=0.65 l=0.15
X8 a_109_297# A1_N VPWR VPB sky130_fd_pr__pfet_01v8_hvt ad=0.105 pd=1.21 as=0.26 ps=2.52 w=1 l=0.15
X9 a_109_47# A1_N VGND VNB sky130_fd_pr__nfet_01v8 ad=0.08775 pd=0.92 as=0.169 ps=1.82 w=0.65 l=0.15
.ends

.subckt sky130_fd_sc_hd__bufinv_16 VNB VPB VGND VPWR A Y
X0 a_361_47# a_27_47# VGND VNB sky130_fd_pr__nfet_01v8 ad=0.08775 pd=0.92 as=0.08775 ps=0.92 w=0.65 l=0.15
X1 VPWR a_361_47# Y VPB sky130_fd_pr__pfet_01v8_hvt ad=0.135 pd=1.27 as=0.135 ps=1.27 w=1 l=0.15
X2 a_361_47# a_27_47# VGND VNB sky130_fd_pr__nfet_01v8 ad=0.08775 pd=0.92 as=0.08775 ps=0.92 w=0.65 l=0.15
X3 Y a_361_47# VGND VNB sky130_fd_pr__nfet_01v8 ad=0.08775 pd=0.92 as=0.08775 ps=0.92 w=0.65 l=0.15
X4 VPWR a_361_47# Y VPB sky130_fd_pr__pfet_01v8_hvt ad=0.135 pd=1.27 as=0.135 ps=1.27 w=1 l=0.15
X5 Y a_361_47# VGND VNB sky130_fd_pr__nfet_01v8 ad=0.08775 pd=0.92 as=0.08775 ps=0.92 w=0.65 l=0.15
X6 Y a_361_47# VPWR VPB sky130_fd_pr__pfet_01v8_hvt ad=0.135 pd=1.27 as=0.135 ps=1.27 w=1 l=0.15
X7 VPWR a_27_47# a_361_47# VPB sky130_fd_pr__pfet_01v8_hvt ad=0.135 pd=1.27 as=0.135 ps=1.27 w=1 l=0.15
X8 VPWR a_361_47# Y VPB sky130_fd_pr__pfet_01v8_hvt ad=0.26 pd=2.52 as=0.135 ps=1.27 w=1 l=0.15
X9 VPWR a_361_47# Y VPB sky130_fd_pr__pfet_01v8_hvt ad=0.135 pd=1.27 as=0.135 ps=1.27 w=1 l=0.15
X10 VGND a_361_47# Y VNB sky130_fd_pr__nfet_01v8 ad=0.169 pd=1.82 as=0.08775 ps=0.92 w=0.65 l=0.15
X11 a_361_47# a_27_47# VPWR VPB sky130_fd_pr__pfet_01v8_hvt ad=0.135 pd=1.27 as=0.135 ps=1.27 w=1 l=0.15
X12 VGND a_361_47# Y VNB sky130_fd_pr__nfet_01v8 ad=0.08775 pd=0.92 as=0.08775 ps=0.92 w=0.65 l=0.15
X13 VGND a_361_47# Y VNB sky130_fd_pr__nfet_01v8 ad=0.08775 pd=0.92 as=0.08775 ps=0.92 w=0.65 l=0.15
X14 VGND a_361_47# Y VNB sky130_fd_pr__nfet_01v8 ad=0.08775 pd=0.92 as=0.08775 ps=0.92 w=0.65 l=0.15
X15 VGND a_361_47# Y VNB sky130_fd_pr__nfet_01v8 ad=0.08775 pd=0.92 as=0.08775 ps=0.92 w=0.65 l=0.15
X16 VPWR A a_27_47# VPB sky130_fd_pr__pfet_01v8_hvt ad=0.135 pd=1.27 as=0.135 ps=1.27 w=1 l=0.15
X17 Y a_361_47# VPWR VPB sky130_fd_pr__pfet_01v8_hvt ad=0.135 pd=1.27 as=0.135 ps=1.27 w=1 l=0.15
X18 VGND a_361_47# Y VNB sky130_fd_pr__nfet_01v8 ad=0.08775 pd=0.92 as=0.08775 ps=0.92 w=0.65 l=0.15
X19 VPWR a_361_47# Y VPB sky130_fd_pr__pfet_01v8_hvt ad=0.135 pd=1.27 as=0.135 ps=1.27 w=1 l=0.15
X20 a_27_47# A VPWR VPB sky130_fd_pr__pfet_01v8_hvt ad=0.135 pd=1.27 as=0.135 ps=1.27 w=1 l=0.15
X21 Y a_361_47# VPWR VPB sky130_fd_pr__pfet_01v8_hvt ad=0.135 pd=1.27 as=0.135 ps=1.27 w=1 l=0.15
X22 a_27_47# A VGND VNB sky130_fd_pr__nfet_01v8 ad=0.08775 pd=0.92 as=0.08775 ps=0.92 w=0.65 l=0.15
X23 a_361_47# a_27_47# VGND VNB sky130_fd_pr__nfet_01v8 ad=0.08775 pd=0.92 as=0.08775 ps=0.92 w=0.65 l=0.15
X24 Y a_361_47# VPWR VPB sky130_fd_pr__pfet_01v8_hvt ad=0.135 pd=1.27 as=0.135 ps=1.27 w=1 l=0.15
X25 Y a_361_47# VGND VNB sky130_fd_pr__nfet_01v8 ad=0.08775 pd=0.92 as=0.08775 ps=0.92 w=0.65 l=0.15
X26 VPWR a_27_47# a_361_47# VPB sky130_fd_pr__pfet_01v8_hvt ad=0.135 pd=1.27 as=0.135 ps=1.27 w=1 l=0.15
X27 Y a_361_47# VGND VNB sky130_fd_pr__nfet_01v8 ad=0.08775 pd=0.92 as=0.08775 ps=0.92 w=0.65 l=0.15
X28 Y a_361_47# VPWR VPB sky130_fd_pr__pfet_01v8_hvt ad=0.135 pd=1.27 as=0.135 ps=1.27 w=1 l=0.15
X29 Y a_361_47# VGND VNB sky130_fd_pr__nfet_01v8 ad=0.08775 pd=0.92 as=0.08775 ps=0.92 w=0.65 l=0.15
X30 a_361_47# a_27_47# VPWR VPB sky130_fd_pr__pfet_01v8_hvt ad=0.135 pd=1.27 as=0.135 ps=1.27 w=1 l=0.15
X31 VPWR a_361_47# Y VPB sky130_fd_pr__pfet_01v8_hvt ad=0.135 pd=1.27 as=0.135 ps=1.27 w=1 l=0.15
X32 Y a_361_47# VGND VNB sky130_fd_pr__nfet_01v8 ad=0.08775 pd=0.92 as=0.08775 ps=0.92 w=0.65 l=0.15
X33 VGND A a_27_47# VNB sky130_fd_pr__nfet_01v8 ad=0.08775 pd=0.92 as=0.08775 ps=0.92 w=0.65 l=0.15
X34 VGND a_27_47# a_361_47# VNB sky130_fd_pr__nfet_01v8 ad=0.08775 pd=0.92 as=0.08775 ps=0.92 w=0.65 l=0.15
X35 VPWR a_27_47# a_361_47# VPB sky130_fd_pr__pfet_01v8_hvt ad=0.135 pd=1.27 as=0.135 ps=1.27 w=1 l=0.15
X36 Y a_361_47# VPWR VPB sky130_fd_pr__pfet_01v8_hvt ad=0.135 pd=1.27 as=0.135 ps=1.27 w=1 l=0.15
X37 VGND a_27_47# a_361_47# VNB sky130_fd_pr__nfet_01v8 ad=0.08775 pd=0.92 as=0.08775 ps=0.92 w=0.65 l=0.15
X38 VGND a_27_47# a_361_47# VNB sky130_fd_pr__nfet_01v8 ad=0.08775 pd=0.92 as=0.08775 ps=0.92 w=0.65 l=0.15
X39 a_361_47# a_27_47# VPWR VPB sky130_fd_pr__pfet_01v8_hvt ad=0.135 pd=1.27 as=0.135 ps=1.27 w=1 l=0.15
X40 VPWR a_361_47# Y VPB sky130_fd_pr__pfet_01v8_hvt ad=0.135 pd=1.27 as=0.135 ps=1.27 w=1 l=0.15
X41 VPWR a_361_47# Y VPB sky130_fd_pr__pfet_01v8_hvt ad=0.135 pd=1.27 as=0.135 ps=1.27 w=1 l=0.15
X42 VGND a_361_47# Y VNB sky130_fd_pr__nfet_01v8 ad=0.08775 pd=0.92 as=0.08775 ps=0.92 w=0.65 l=0.15
X43 VGND a_361_47# Y VNB sky130_fd_pr__nfet_01v8 ad=0.08775 pd=0.92 as=0.08775 ps=0.92 w=0.65 l=0.15
X44 VPWR A a_27_47# VPB sky130_fd_pr__pfet_01v8_hvt ad=0.135 pd=1.27 as=0.26 ps=2.52 w=1 l=0.15
X45 Y a_361_47# VPWR VPB sky130_fd_pr__pfet_01v8_hvt ad=0.135 pd=1.27 as=0.135 ps=1.27 w=1 l=0.15
X46 Y a_361_47# VGND VNB sky130_fd_pr__nfet_01v8 ad=0.08775 pd=0.92 as=0.08775 ps=0.92 w=0.65 l=0.15
X47 Y a_361_47# VPWR VPB sky130_fd_pr__pfet_01v8_hvt ad=0.135 pd=1.27 as=0.135 ps=1.27 w=1 l=0.15
X48 VGND A a_27_47# VNB sky130_fd_pr__nfet_01v8 ad=0.08775 pd=0.92 as=0.169 ps=1.82 w=0.65 l=0.15
X49 Y a_361_47# VGND VNB sky130_fd_pr__nfet_01v8 ad=0.08775 pd=0.92 as=0.08775 ps=0.92 w=0.65 l=0.15
.ends

.subckt sky130_fd_sc_hd__clkbuf_8 X A VPB VNB VGND VPWR
X0 VPWR A a_110_47# VPB sky130_fd_pr__pfet_01v8_hvt ad=0.14 pd=1.28 as=0.14 ps=1.28 w=1 l=0.15
X1 VPWR a_110_47# X VPB sky130_fd_pr__pfet_01v8_hvt ad=0.14 pd=1.28 as=0.14 ps=1.28 w=1 l=0.15
X2 X a_110_47# VPWR VPB sky130_fd_pr__pfet_01v8_hvt ad=0.14 pd=1.28 as=0.14 ps=1.28 w=1 l=0.15
X3 a_110_47# A VPWR VPB sky130_fd_pr__pfet_01v8_hvt ad=0.14 pd=1.28 as=0.265 ps=2.53 w=1 l=0.15
X4 X a_110_47# VGND VNB sky130_fd_pr__nfet_01v8 ad=0.0588 pd=0.7 as=0.0588 ps=0.7 w=0.42 l=0.15
X5 X a_110_47# VPWR VPB sky130_fd_pr__pfet_01v8_hvt ad=0.14 pd=1.28 as=0.14 ps=1.28 w=1 l=0.15
X6 VGND a_110_47# X VNB sky130_fd_pr__nfet_01v8 ad=0.0588 pd=0.7 as=0.0588 ps=0.7 w=0.42 l=0.15
X7 VPWR a_110_47# X VPB sky130_fd_pr__pfet_01v8_hvt ad=0.14 pd=1.28 as=0.14 ps=1.28 w=1 l=0.15
X8 VGND A a_110_47# VNB sky130_fd_pr__nfet_01v8 ad=0.0588 pd=0.7 as=0.0588 ps=0.7 w=0.42 l=0.15
X9 VGND a_110_47# X VNB sky130_fd_pr__nfet_01v8 ad=0.1134 pd=1.38 as=0.0588 ps=0.7 w=0.42 l=0.15
X10 a_110_47# A VGND VNB sky130_fd_pr__nfet_01v8 ad=0.0588 pd=0.7 as=0.1113 ps=1.37 w=0.42 l=0.15
X11 VPWR a_110_47# X VPB sky130_fd_pr__pfet_01v8_hvt ad=0.14 pd=1.28 as=0.14 ps=1.28 w=1 l=0.15
X12 X a_110_47# VPWR VPB sky130_fd_pr__pfet_01v8_hvt ad=0.14 pd=1.28 as=0.14 ps=1.28 w=1 l=0.15
X13 VGND a_110_47# X VNB sky130_fd_pr__nfet_01v8 ad=0.0588 pd=0.7 as=0.0588 ps=0.7 w=0.42 l=0.15
X14 VGND a_110_47# X VNB sky130_fd_pr__nfet_01v8 ad=0.0588 pd=0.7 as=0.0588 ps=0.7 w=0.42 l=0.15
X15 X a_110_47# VPWR VPB sky130_fd_pr__pfet_01v8_hvt ad=0.14 pd=1.28 as=0.14 ps=1.28 w=1 l=0.15
X16 X a_110_47# VGND VNB sky130_fd_pr__nfet_01v8 ad=0.0588 pd=0.7 as=0.0588 ps=0.7 w=0.42 l=0.15
X17 VPWR a_110_47# X VPB sky130_fd_pr__pfet_01v8_hvt ad=0.265 pd=2.53 as=0.14 ps=1.28 w=1 l=0.15
X18 X a_110_47# VGND VNB sky130_fd_pr__nfet_01v8 ad=0.0588 pd=0.7 as=0.0588 ps=0.7 w=0.42 l=0.15
X19 X a_110_47# VGND VNB sky130_fd_pr__nfet_01v8 ad=0.0588 pd=0.7 as=0.0588 ps=0.7 w=0.42 l=0.15
.ends

.subckt sky130_fd_sc_hd__o21bai_1 VPB VNB VPWR VGND A1 B1_N Y A2
X0 a_388_297# A2 Y VPB sky130_fd_pr__pfet_01v8_hvt ad=0.1275 pd=1.255 as=0.1525 ps=1.305 w=1 l=0.15
X1 a_105_352# B1_N VGND VNB sky130_fd_pr__nfet_01v8 ad=0.1092 pd=1.36 as=0.1092 ps=1.36 w=0.42 l=0.15
X2 a_297_47# a_105_352# Y VNB sky130_fd_pr__nfet_01v8 ad=0.10075 pd=0.96 as=0.169 ps=1.82 w=0.65 l=0.15
X3 a_297_47# A1 VGND VNB sky130_fd_pr__nfet_01v8 ad=0.169 pd=1.82 as=0.08775 ps=0.92 w=0.65 l=0.15
X4 VPWR A1 a_388_297# VPB sky130_fd_pr__pfet_01v8_hvt ad=0.28 pd=2.56 as=0.1275 ps=1.255 w=1 l=0.15
X5 VGND A2 a_297_47# VNB sky130_fd_pr__nfet_01v8 ad=0.08775 pd=0.92 as=0.10075 ps=0.96 w=0.65 l=0.15
X6 VPWR B1_N a_105_352# VPB sky130_fd_pr__pfet_01v8_hvt ad=0.17825 pd=1.4 as=0.1092 ps=1.36 w=0.42 l=0.15
X7 Y a_105_352# VPWR VPB sky130_fd_pr__pfet_01v8_hvt ad=0.1525 pd=1.305 as=0.17825 ps=1.4 w=1 l=0.15
.ends

.subckt sky130_fd_sc_hd__inv_6 VPB VNB VPWR VGND Y A
X0 VPWR A Y VPB sky130_fd_pr__pfet_01v8_hvt ad=0.27 pd=2.54 as=0.135 ps=1.27 w=1 l=0.15
X1 Y A VPWR VPB sky130_fd_pr__pfet_01v8_hvt ad=0.135 pd=1.27 as=0.135 ps=1.27 w=1 l=0.15
X2 Y A VGND VNB sky130_fd_pr__nfet_01v8 ad=0.08775 pd=0.92 as=0.08775 ps=0.92 w=0.65 l=0.15
X3 VPWR A Y VPB sky130_fd_pr__pfet_01v8_hvt ad=0.135 pd=1.27 as=0.135 ps=1.27 w=1 l=0.15
X4 Y A VPWR VPB sky130_fd_pr__pfet_01v8_hvt ad=0.135 pd=1.27 as=0.135 ps=1.27 w=1 l=0.15
X5 VPWR A Y VPB sky130_fd_pr__pfet_01v8_hvt ad=0.135 pd=1.27 as=0.135 ps=1.27 w=1 l=0.15
X6 Y A VGND VNB sky130_fd_pr__nfet_01v8 ad=0.08775 pd=0.92 as=0.247 ps=2.06 w=0.65 l=0.15
X7 Y A VGND VNB sky130_fd_pr__nfet_01v8 ad=0.08775 pd=0.92 as=0.08775 ps=0.92 w=0.65 l=0.15
X8 Y A VPWR VPB sky130_fd_pr__pfet_01v8_hvt ad=0.135 pd=1.27 as=0.43 ps=2.86 w=1 l=0.15
X9 VGND A Y VNB sky130_fd_pr__nfet_01v8 ad=0.08775 pd=0.92 as=0.08775 ps=0.92 w=0.65 l=0.15
X10 VGND A Y VNB sky130_fd_pr__nfet_01v8 ad=0.08775 pd=0.92 as=0.08775 ps=0.92 w=0.65 l=0.15
X11 VGND A Y VNB sky130_fd_pr__nfet_01v8 ad=0.1755 pd=1.84 as=0.08775 ps=0.92 w=0.65 l=0.15
.ends

.subckt sky130_fd_sc_hd__inv_16 VPB VNB VGND VPWR Y A
X0 Y A VPWR VPB sky130_fd_pr__pfet_01v8_hvt ad=0.135 pd=1.27 as=0.135 ps=1.27 w=1 l=0.15
X1 VPWR A Y VPB sky130_fd_pr__pfet_01v8_hvt ad=0.26 pd=2.52 as=0.135 ps=1.27 w=1 l=0.15
X2 VGND A Y VNB sky130_fd_pr__nfet_01v8 ad=0.08775 pd=0.92 as=0.08775 ps=0.92 w=0.65 l=0.15
X3 Y A VPWR VPB sky130_fd_pr__pfet_01v8_hvt ad=0.135 pd=1.27 as=0.135 ps=1.27 w=1 l=0.15
X4 VGND A Y VNB sky130_fd_pr__nfet_01v8 ad=0.08775 pd=0.92 as=0.08775 ps=0.92 w=0.65 l=0.15
X5 VGND A Y VNB sky130_fd_pr__nfet_01v8 ad=0.08775 pd=0.92 as=0.08775 ps=0.92 w=0.65 l=0.15
X6 Y A VPWR VPB sky130_fd_pr__pfet_01v8_hvt ad=0.135 pd=1.27 as=0.26 ps=2.52 w=1 l=0.15
X7 VGND A Y VNB sky130_fd_pr__nfet_01v8 ad=0.169 pd=1.82 as=0.08775 ps=0.92 w=0.65 l=0.15
X8 VPWR A Y VPB sky130_fd_pr__pfet_01v8_hvt ad=0.135 pd=1.27 as=0.135 ps=1.27 w=1 l=0.15
X9 Y A VGND VNB sky130_fd_pr__nfet_01v8 ad=0.08775 pd=0.92 as=0.08775 ps=0.92 w=0.65 l=0.15
X10 VPWR A Y VPB sky130_fd_pr__pfet_01v8_hvt ad=0.135 pd=1.27 as=0.135 ps=1.27 w=1 l=0.15
X11 Y A VGND VNB sky130_fd_pr__nfet_01v8 ad=0.08775 pd=0.92 as=0.08775 ps=0.92 w=0.65 l=0.15
X12 Y A VPWR VPB sky130_fd_pr__pfet_01v8_hvt ad=0.135 pd=1.27 as=0.135 ps=1.27 w=1 l=0.15
X13 VPWR A Y VPB sky130_fd_pr__pfet_01v8_hvt ad=0.135 pd=1.27 as=0.135 ps=1.27 w=1 l=0.15
X14 Y A VPWR VPB sky130_fd_pr__pfet_01v8_hvt ad=0.135 pd=1.27 as=0.135 ps=1.27 w=1 l=0.15
X15 VGND A Y VNB sky130_fd_pr__nfet_01v8 ad=0.08775 pd=0.92 as=0.08775 ps=0.92 w=0.65 l=0.15
X16 Y A VGND VNB sky130_fd_pr__nfet_01v8 ad=0.08775 pd=0.92 as=0.169 ps=1.82 w=0.65 l=0.15
X17 VGND A Y VNB sky130_fd_pr__nfet_01v8 ad=0.08775 pd=0.92 as=0.08775 ps=0.92 w=0.65 l=0.15
X18 VGND A Y VNB sky130_fd_pr__nfet_01v8 ad=0.08775 pd=0.92 as=0.08775 ps=0.92 w=0.65 l=0.15
X19 Y A VPWR VPB sky130_fd_pr__pfet_01v8_hvt ad=0.135 pd=1.27 as=0.135 ps=1.27 w=1 l=0.15
X20 VGND A Y VNB sky130_fd_pr__nfet_01v8 ad=0.08775 pd=0.92 as=0.08775 ps=0.92 w=0.65 l=0.15
X21 Y A VPWR VPB sky130_fd_pr__pfet_01v8_hvt ad=0.135 pd=1.27 as=0.135 ps=1.27 w=1 l=0.15
X22 VPWR A Y VPB sky130_fd_pr__pfet_01v8_hvt ad=0.135 pd=1.27 as=0.135 ps=1.27 w=1 l=0.15
X23 VPWR A Y VPB sky130_fd_pr__pfet_01v8_hvt ad=0.135 pd=1.27 as=0.135 ps=1.27 w=1 l=0.15
X24 VPWR A Y VPB sky130_fd_pr__pfet_01v8_hvt ad=0.135 pd=1.27 as=0.135 ps=1.27 w=1 l=0.15
X25 Y A VGND VNB sky130_fd_pr__nfet_01v8 ad=0.08775 pd=0.92 as=0.08775 ps=0.92 w=0.65 l=0.15
X26 Y A VPWR VPB sky130_fd_pr__pfet_01v8_hvt ad=0.135 pd=1.27 as=0.135 ps=1.27 w=1 l=0.15
X27 Y A VGND VNB sky130_fd_pr__nfet_01v8 ad=0.08775 pd=0.92 as=0.08775 ps=0.92 w=0.65 l=0.15
X28 Y A VGND VNB sky130_fd_pr__nfet_01v8 ad=0.08775 pd=0.92 as=0.08775 ps=0.92 w=0.65 l=0.15
X29 Y A VGND VNB sky130_fd_pr__nfet_01v8 ad=0.08775 pd=0.92 as=0.08775 ps=0.92 w=0.65 l=0.15
X30 VPWR A Y VPB sky130_fd_pr__pfet_01v8_hvt ad=0.135 pd=1.27 as=0.135 ps=1.27 w=1 l=0.15
X31 Y A VGND VNB sky130_fd_pr__nfet_01v8 ad=0.08775 pd=0.92 as=0.08775 ps=0.92 w=0.65 l=0.15
.ends

.subckt sky130_fd_sc_hd__buf_1 VGND VPWR X A VPB VNB
X0 VPWR A a_27_47# VPB sky130_fd_pr__pfet_01v8_hvt ad=0.11455 pd=1.08 as=0.2054 ps=2.1 w=0.79 l=0.15
X1 X a_27_47# VGND VNB sky130_fd_pr__nfet_01v8 ad=0.1352 pd=1.56 as=0.0754 ps=0.81 w=0.52 l=0.15
X2 X a_27_47# VPWR VPB sky130_fd_pr__pfet_01v8_hvt ad=0.2054 pd=2.1 as=0.11455 ps=1.08 w=0.79 l=0.15
X3 VGND A a_27_47# VNB sky130_fd_pr__nfet_01v8 ad=0.0754 pd=0.81 as=0.1352 ps=1.56 w=0.52 l=0.15
.ends

.subckt sky130_fd_sc_hd__o2111a_1 VNB VPB VPWR VGND X D1 C1 B1 A2 A1
X0 a_676_297# A2 a_79_21# VPB sky130_fd_pr__pfet_01v8_hvt ad=0.105 pd=1.21 as=0.2125 ps=1.425 w=1 l=0.15
X1 a_512_47# B1 a_409_47# VNB sky130_fd_pr__nfet_01v8 ad=0.19825 pd=1.26 as=0.11863 ps=1.015 w=0.65 l=0.15
X2 a_306_47# D1 a_79_21# VNB sky130_fd_pr__nfet_01v8 ad=0.11863 pd=1.015 as=0.19825 ps=1.91 w=0.65 l=0.15
X3 VGND A2 a_512_47# VNB sky130_fd_pr__nfet_01v8 ad=0.08775 pd=0.92 as=0.19825 ps=1.26 w=0.65 l=0.15
X4 VPWR C1 a_79_21# VPB sky130_fd_pr__pfet_01v8_hvt ad=0.305 pd=1.61 as=0.2175 ps=1.435 w=1 l=0.15
X5 a_79_21# B1 VPWR VPB sky130_fd_pr__pfet_01v8_hvt ad=0.2125 pd=1.425 as=0.305 ps=1.61 w=1 l=0.15
X6 VPWR A1 a_676_297# VPB sky130_fd_pr__pfet_01v8_hvt ad=0.265 pd=2.53 as=0.105 ps=1.21 w=1 l=0.15
X7 a_512_47# A1 VGND VNB sky130_fd_pr__nfet_01v8 ad=0.17225 pd=1.83 as=0.08775 ps=0.92 w=0.65 l=0.15
X8 a_409_47# C1 a_306_47# VNB sky130_fd_pr__nfet_01v8 ad=0.11863 pd=1.015 as=0.11863 ps=1.015 w=0.65 l=0.15
X9 VPWR a_79_21# X VPB sky130_fd_pr__pfet_01v8_hvt ad=0.3825 pd=1.765 as=0.26 ps=2.52 w=1 l=0.15
X10 a_79_21# D1 VPWR VPB sky130_fd_pr__pfet_01v8_hvt ad=0.2175 pd=1.435 as=0.3825 ps=1.765 w=1 l=0.15
X11 VGND a_79_21# X VNB sky130_fd_pr__nfet_01v8 ad=0.169 pd=1.82 as=0.169 ps=1.82 w=0.65 l=0.15
.ends

.subckt sky130_fd_sc_hd__a211o_1 VNB VPB VGND VPWR X A2 B1 A1 C1
X0 VPWR a_80_21# X VPB sky130_fd_pr__pfet_01v8_hvt ad=0.265 pd=2.53 as=0.265 ps=2.53 w=1 l=0.15
X1 a_80_21# C1 a_472_297# VPB sky130_fd_pr__pfet_01v8_hvt ad=0.265 pd=2.53 as=0.155 ps=1.31 w=1 l=0.15
X2 VPWR A2 a_217_297# VPB sky130_fd_pr__pfet_01v8_hvt ad=0.14 pd=1.28 as=0.265 ps=2.53 w=1 l=0.15
X3 VGND B1 a_80_21# VNB sky130_fd_pr__nfet_01v8 ad=0.10075 pd=0.96 as=0.091 ps=0.93 w=0.65 l=0.15
X4 VGND a_80_21# X VNB sky130_fd_pr__nfet_01v8 ad=0.26 pd=1.45 as=0.17225 ps=1.83 w=0.65 l=0.15
X5 a_300_47# A2 VGND VNB sky130_fd_pr__nfet_01v8 ad=0.091 pd=0.93 as=0.26 ps=1.45 w=0.65 l=0.15
X6 a_217_297# A1 VPWR VPB sky130_fd_pr__pfet_01v8_hvt ad=0.14 pd=1.28 as=0.14 ps=1.28 w=1 l=0.15
X7 a_80_21# A1 a_300_47# VNB sky130_fd_pr__nfet_01v8 ad=0.091 pd=0.93 as=0.091 ps=0.93 w=0.65 l=0.15
X8 a_472_297# B1 a_217_297# VPB sky130_fd_pr__pfet_01v8_hvt ad=0.155 pd=1.31 as=0.14 ps=1.28 w=1 l=0.15
X9 a_80_21# C1 VGND VNB sky130_fd_pr__nfet_01v8 ad=0.17225 pd=1.83 as=0.10075 ps=0.96 w=0.65 l=0.15
.ends

.subckt sky130_fd_sc_hd__or3_1 VPWR VGND VPB VNB B C A X
X0 X a_29_53# VPWR VPB sky130_fd_pr__pfet_01v8_hvt ad=0.28 pd=2.56 as=0.14825 ps=1.34 w=1 l=0.15
X1 a_111_297# C a_29_53# VPB sky130_fd_pr__pfet_01v8_hvt ad=0.0441 pd=0.63 as=0.1092 ps=1.36 w=0.42 l=0.15
X2 X a_29_53# VGND VNB sky130_fd_pr__nfet_01v8 ad=0.182 pd=1.86 as=0.10187 ps=0.99 w=0.65 l=0.15
X3 a_183_297# B a_111_297# VPB sky130_fd_pr__pfet_01v8_hvt ad=0.0693 pd=0.75 as=0.0441 ps=0.63 w=0.42 l=0.15
X4 VPWR A a_183_297# VPB sky130_fd_pr__pfet_01v8_hvt ad=0.14825 pd=1.34 as=0.0693 ps=0.75 w=0.42 l=0.15
X5 a_29_53# B VGND VNB sky130_fd_pr__nfet_01v8 ad=0.0567 pd=0.69 as=0.0567 ps=0.69 w=0.42 l=0.15
X6 VGND C a_29_53# VNB sky130_fd_pr__nfet_01v8 ad=0.0567 pd=0.69 as=0.1092 ps=1.36 w=0.42 l=0.15
X7 VGND A a_29_53# VNB sky130_fd_pr__nfet_01v8 ad=0.10187 pd=0.99 as=0.0567 ps=0.69 w=0.42 l=0.15
.ends

.subckt sky130_fd_sc_hd__o2111ai_1 VPB VNB VGND VPWR Y A1 A2 C1 D1 B1
X0 VPWR C1 Y VPB sky130_fd_pr__pfet_01v8_hvt ad=0.195 pd=1.39 as=0.14 ps=1.28 w=1 l=0.15
X1 a_235_47# C1 a_163_47# VNB sky130_fd_pr__nfet_01v8 ad=0.12675 pd=1.04 as=0.06825 ps=0.86 w=0.65 l=0.15
X2 a_343_47# B1 a_235_47# VNB sky130_fd_pr__nfet_01v8 ad=0.13162 pd=1.055 as=0.12675 ps=1.04 w=0.65 l=0.15
X3 Y B1 VPWR VPB sky130_fd_pr__pfet_01v8_hvt ad=0.2025 pd=1.405 as=0.195 ps=1.39 w=1 l=0.15
X4 a_454_297# A2 Y VPB sky130_fd_pr__pfet_01v8_hvt ad=0.195 pd=1.39 as=0.2025 ps=1.405 w=1 l=0.15
X5 Y D1 VPWR VPB sky130_fd_pr__pfet_01v8_hvt ad=0.14 pd=1.28 as=0.265 ps=2.53 w=1 l=0.15
X6 VPWR A1 a_454_297# VPB sky130_fd_pr__pfet_01v8_hvt ad=0.265 pd=2.53 as=0.195 ps=1.39 w=1 l=0.15
X7 a_163_47# D1 Y VNB sky130_fd_pr__nfet_01v8 ad=0.06825 pd=0.86 as=0.17225 ps=1.83 w=0.65 l=0.15
X8 VGND A2 a_343_47# VNB sky130_fd_pr__nfet_01v8 ad=0.12675 pd=1.04 as=0.13162 ps=1.055 w=0.65 l=0.15
X9 a_343_47# A1 VGND VNB sky130_fd_pr__nfet_01v8 ad=0.17225 pd=1.83 as=0.12675 ps=1.04 w=0.65 l=0.15
.ends

.subckt sky130_fd_sc_hd__clkbuf_2 VGND VPWR A X VPB VNB
X0 VPWR A a_27_47# VPB sky130_fd_pr__pfet_01v8_hvt ad=0.1625 pd=1.325 as=0.265 ps=2.53 w=1 l=0.15
X1 VPWR a_27_47# X VPB sky130_fd_pr__pfet_01v8_hvt ad=0.26 pd=2.52 as=0.135 ps=1.27 w=1 l=0.15
X2 VGND A a_27_47# VNB sky130_fd_pr__nfet_01v8 ad=0.06825 pd=0.745 as=0.1113 ps=1.37 w=0.42 l=0.15
X3 X a_27_47# VPWR VPB sky130_fd_pr__pfet_01v8_hvt ad=0.135 pd=1.27 as=0.1625 ps=1.325 w=1 l=0.15
X4 X a_27_47# VGND VNB sky130_fd_pr__nfet_01v8 ad=0.0567 pd=0.69 as=0.06825 ps=0.745 w=0.42 l=0.15
X5 VGND a_27_47# X VNB sky130_fd_pr__nfet_01v8 ad=0.1092 pd=1.36 as=0.0567 ps=0.69 w=0.42 l=0.15
.ends

.subckt sky130_fd_sc_hd__o21ba_1 VNB VPB VGND VPWR B1_N A1 A2 X
X0 a_222_93# B1_N VGND VNB sky130_fd_pr__nfet_01v8 ad=0.1092 pd=1.36 as=0.10025 ps=0.985 w=0.42 l=0.15
X1 VPWR A1 a_544_297# VPB sky130_fd_pr__pfet_01v8_hvt ad=0.28 pd=2.56 as=0.105 ps=1.21 w=1 l=0.15
X2 VGND a_79_199# X VNB sky130_fd_pr__nfet_01v8 ad=0.10025 pd=0.985 as=0.169 ps=1.82 w=0.65 l=0.15
X3 a_222_93# B1_N VPWR VPB sky130_fd_pr__pfet_01v8_hvt ad=0.1176 pd=1.4 as=0.18575 ps=1.415 w=0.42 l=0.15
X4 VGND A2 a_448_47# VNB sky130_fd_pr__nfet_01v8 ad=0.08775 pd=0.92 as=0.10725 ps=0.98 w=0.65 l=0.15
X5 a_448_47# a_222_93# a_79_199# VNB sky130_fd_pr__nfet_01v8 ad=0.10725 pd=0.98 as=0.169 ps=1.82 w=0.65 l=0.15
X6 a_79_199# a_222_93# VPWR VPB sky130_fd_pr__pfet_01v8_hvt ad=0.165 pd=1.33 as=0.3 ps=2.6 w=1 l=0.15
X7 a_544_297# A2 a_79_199# VPB sky130_fd_pr__pfet_01v8_hvt ad=0.105 pd=1.21 as=0.165 ps=1.33 w=1 l=0.15
X8 a_448_47# A1 VGND VNB sky130_fd_pr__nfet_01v8 ad=0.17225 pd=1.83 as=0.08775 ps=0.92 w=0.65 l=0.15
X9 VPWR a_79_199# X VPB sky130_fd_pr__pfet_01v8_hvt ad=0.18575 pd=1.415 as=0.26 ps=2.52 w=1 l=0.15
.ends

.subckt sky130_fd_sc_hd__nand4b_1 VPB VNB VGND VPWR Y C B D A_N
X0 Y B VPWR VPB sky130_fd_pr__pfet_01v8_hvt ad=0.195 pd=1.39 as=0.1925 ps=1.385 w=1 l=0.15
X1 a_232_47# D VGND VNB sky130_fd_pr__nfet_01v8 ad=0.08775 pd=0.92 as=0.11812 ps=1.04 w=0.65 l=0.15
X2 VPWR C Y VPB sky130_fd_pr__pfet_01v8_hvt ad=0.1925 pd=1.385 as=0.135 ps=1.27 w=1 l=0.15
X3 VPWR A_N a_41_93# VPB sky130_fd_pr__pfet_01v8_hvt ad=0.14575 pd=1.335 as=0.1092 ps=1.36 w=0.42 l=0.15
X4 VPWR a_41_93# Y VPB sky130_fd_pr__pfet_01v8_hvt ad=0.28 pd=2.56 as=0.195 ps=1.39 w=1 l=0.15
X5 a_316_47# C a_232_47# VNB sky130_fd_pr__nfet_01v8 ad=0.12513 pd=1.035 as=0.08775 ps=0.92 w=0.65 l=0.15
X6 Y a_41_93# a_423_47# VNB sky130_fd_pr__nfet_01v8 ad=0.2275 pd=2 as=0.12675 ps=1.04 w=0.65 l=0.15
X7 a_423_47# B a_316_47# VNB sky130_fd_pr__nfet_01v8 ad=0.12675 pd=1.04 as=0.12513 ps=1.035 w=0.65 l=0.15
X8 Y D VPWR VPB sky130_fd_pr__pfet_01v8_hvt ad=0.135 pd=1.27 as=0.14575 ps=1.335 w=1 l=0.15
X9 VGND A_N a_41_93# VNB sky130_fd_pr__nfet_01v8 ad=0.11812 pd=1.04 as=0.1113 ps=1.37 w=0.42 l=0.15
.ends

.subckt sky130_fd_sc_hd__o41ai_2 VNB VPB VGND VPWR A1 A2 A3 A4 Y B1
X0 a_27_47# A2 VGND VNB sky130_fd_pr__nfet_01v8 ad=0.08775 pd=0.92 as=0.08775 ps=0.92 w=0.65 l=0.15
X1 VGND A4 a_27_47# VNB sky130_fd_pr__nfet_01v8 ad=0.08775 pd=0.92 as=0.08775 ps=0.92 w=0.65 l=0.15
X2 VGND A3 a_27_47# VNB sky130_fd_pr__nfet_01v8 ad=0.182 pd=1.86 as=0.08775 ps=0.92 w=0.65 l=0.15
X3 VGND A2 a_27_47# VNB sky130_fd_pr__nfet_01v8 ad=0.08775 pd=0.92 as=0.182 ps=1.86 w=0.65 l=0.15
X4 VGND A1 a_27_47# VNB sky130_fd_pr__nfet_01v8 ad=0.08775 pd=0.92 as=0.08775 ps=0.92 w=0.65 l=0.15
X5 a_27_47# A3 VGND VNB sky130_fd_pr__nfet_01v8 ad=0.08775 pd=0.92 as=0.08775 ps=0.92 w=0.65 l=0.15
X6 VPWR B1 Y VPB sky130_fd_pr__pfet_01v8_hvt ad=0.26 pd=2.52 as=0.135 ps=1.27 w=1 l=0.15
X7 a_27_47# B1 Y VNB sky130_fd_pr__nfet_01v8 ad=0.169 pd=1.82 as=0.08775 ps=0.92 w=0.65 l=0.15
X8 a_299_297# A3 a_549_297# VPB sky130_fd_pr__pfet_01v8_hvt ad=0.28 pd=2.56 as=0.135 ps=1.27 w=1 l=0.15
X9 a_549_297# A3 a_299_297# VPB sky130_fd_pr__pfet_01v8_hvt ad=0.135 pd=1.27 as=0.135 ps=1.27 w=1 l=0.15
X10 a_299_297# A4 Y VPB sky130_fd_pr__pfet_01v8_hvt ad=0.135 pd=1.27 as=0.135 ps=1.27 w=1 l=0.15
X11 Y A4 a_299_297# VPB sky130_fd_pr__pfet_01v8_hvt ad=0.135 pd=1.27 as=0.26 ps=2.52 w=1 l=0.15
X12 a_743_297# A1 VPWR VPB sky130_fd_pr__pfet_01v8_hvt ad=0.28 pd=2.56 as=0.135 ps=1.27 w=1 l=0.15
X13 VPWR A1 a_743_297# VPB sky130_fd_pr__pfet_01v8_hvt ad=0.135 pd=1.27 as=0.135 ps=1.27 w=1 l=0.15
X14 a_743_297# A2 a_549_297# VPB sky130_fd_pr__pfet_01v8_hvt ad=0.135 pd=1.27 as=0.135 ps=1.27 w=1 l=0.15
X15 a_27_47# A4 VGND VNB sky130_fd_pr__nfet_01v8 ad=0.08775 pd=0.92 as=0.169 ps=1.82 w=0.65 l=0.15
X16 Y B1 VPWR VPB sky130_fd_pr__pfet_01v8_hvt ad=0.135 pd=1.27 as=0.26 ps=2.52 w=1 l=0.15
X17 a_27_47# A1 VGND VNB sky130_fd_pr__nfet_01v8 ad=0.182 pd=1.86 as=0.08775 ps=0.92 w=0.65 l=0.15
X18 a_549_297# A2 a_743_297# VPB sky130_fd_pr__pfet_01v8_hvt ad=0.135 pd=1.27 as=0.28 ps=2.56 w=1 l=0.15
X19 Y B1 a_27_47# VNB sky130_fd_pr__nfet_01v8 ad=0.08775 pd=0.92 as=0.169 ps=1.82 w=0.65 l=0.15
.ends

.subckt sky130_fd_sc_hd__o211ai_1 VPB VNB VGND VPWR A1 Y C1 B1 A2
X0 a_110_297# A1 VPWR VPB sky130_fd_pr__pfet_01v8_hvt ad=0.105 pd=1.21 as=0.265 ps=2.53 w=1 l=0.15
X1 VGND A1 a_27_47# VNB sky130_fd_pr__nfet_01v8 ad=0.12675 pd=1.04 as=0.17225 ps=1.83 w=0.65 l=0.15
X2 Y A2 a_110_297# VPB sky130_fd_pr__pfet_01v8_hvt ad=0.195 pd=1.39 as=0.105 ps=1.21 w=1 l=0.15
X3 VPWR B1 Y VPB sky130_fd_pr__pfet_01v8_hvt ad=0.195 pd=1.39 as=0.195 ps=1.39 w=1 l=0.15
X4 a_27_47# A2 VGND VNB sky130_fd_pr__nfet_01v8 ad=0.12675 pd=1.04 as=0.12675 ps=1.04 w=0.65 l=0.15
X5 a_326_47# B1 a_27_47# VNB sky130_fd_pr__nfet_01v8 ad=0.06825 pd=0.86 as=0.12675 ps=1.04 w=0.65 l=0.15
X6 Y C1 VPWR VPB sky130_fd_pr__pfet_01v8_hvt ad=0.635 pd=3.27 as=0.195 ps=1.39 w=1 l=0.15
X7 Y C1 a_326_47# VNB sky130_fd_pr__nfet_01v8 ad=0.39325 pd=2.51 as=0.06825 ps=0.86 w=0.65 l=0.15
.ends

.subckt sky130_fd_sc_hd__nand3b_1 VPB VNB VGND VPWR Y B C A_N
X0 Y a_53_93# VPWR VPB sky130_fd_pr__pfet_01v8_hvt ad=0.28 pd=2.56 as=0.1925 ps=1.385 w=1 l=0.15
X1 a_232_47# C VGND VNB sky130_fd_pr__nfet_01v8 ad=0.08775 pd=0.92 as=0.10025 ps=0.985 w=0.65 l=0.15
X2 VPWR B Y VPB sky130_fd_pr__pfet_01v8_hvt ad=0.1925 pd=1.385 as=0.135 ps=1.27 w=1 l=0.15
X3 VPWR A_N a_53_93# VPB sky130_fd_pr__pfet_01v8_hvt ad=0.14575 pd=1.335 as=0.1092 ps=1.36 w=0.42 l=0.15
X4 VGND A_N a_53_93# VNB sky130_fd_pr__nfet_01v8 ad=0.10025 pd=0.985 as=0.1092 ps=1.36 w=0.42 l=0.15
X5 a_316_47# B a_232_47# VNB sky130_fd_pr__nfet_01v8 ad=0.12513 pd=1.035 as=0.08775 ps=0.92 w=0.65 l=0.15
X6 Y a_53_93# a_316_47# VNB sky130_fd_pr__nfet_01v8 ad=0.182 pd=1.86 as=0.12513 ps=1.035 w=0.65 l=0.15
X7 Y C VPWR VPB sky130_fd_pr__pfet_01v8_hvt ad=0.135 pd=1.27 as=0.14575 ps=1.335 w=1 l=0.15
.ends

.subckt sky130_fd_sc_hd__o41a_1 VPB VNB VGND VPWR X B1 A4 A3 A2 A1
X0 VGND A4 a_321_47# VNB sky130_fd_pr__nfet_01v8 ad=0.1235 pd=1.03 as=0.08775 ps=0.92 w=0.65 l=0.15
X1 a_321_47# A3 VGND VNB sky130_fd_pr__nfet_01v8 ad=0.12675 pd=1.04 as=0.1235 ps=1.03 w=0.65 l=0.15
X2 a_103_21# B1 VPWR VPB sky130_fd_pr__pfet_01v8_hvt ad=0.26 pd=1.52 as=0.135 ps=1.27 w=1 l=0.15
X3 VPWR a_103_21# X VPB sky130_fd_pr__pfet_01v8_hvt ad=0.135 pd=1.27 as=0.425 ps=2.85 w=1 l=0.15
X4 VGND a_103_21# X VNB sky130_fd_pr__nfet_01v8 ad=0.169 pd=1.82 as=0.247 ps=2.06 w=0.65 l=0.15
X5 VGND A2 a_321_47# VNB sky130_fd_pr__nfet_01v8 ad=0.12675 pd=1.04 as=0.12675 ps=1.04 w=0.65 l=0.15
X6 a_321_47# A1 VGND VNB sky130_fd_pr__nfet_01v8 ad=0.195 pd=1.9 as=0.12675 ps=1.04 w=0.65 l=0.15
X7 a_511_297# A3 a_393_297# VPB sky130_fd_pr__pfet_01v8_hvt ad=0.195 pd=1.39 as=0.22 ps=1.44 w=1 l=0.15
X8 a_619_297# A2 a_511_297# VPB sky130_fd_pr__pfet_01v8_hvt ad=0.195 pd=1.39 as=0.195 ps=1.39 w=1 l=0.15
X9 a_321_47# B1 a_103_21# VNB sky130_fd_pr__nfet_01v8 ad=0.08775 pd=0.92 as=0.169 ps=1.82 w=0.65 l=0.15
X10 a_393_297# A4 a_103_21# VPB sky130_fd_pr__pfet_01v8_hvt ad=0.22 pd=1.44 as=0.26 ps=1.52 w=1 l=0.15
X11 VPWR A1 a_619_297# VPB sky130_fd_pr__pfet_01v8_hvt ad=0.28 pd=2.56 as=0.195 ps=1.39 w=1 l=0.15
.ends

.subckt sky130_fd_sc_hd__o32ai_1 VPB VNB VGND VPWR A1 A2 B1 Y B2 A3
X0 VGND A3 a_27_47# VNB sky130_fd_pr__nfet_01v8 ad=0.21937 pd=1.325 as=0.10075 ps=0.96 w=0.65 l=0.15
X1 a_27_47# A2 VGND VNB sky130_fd_pr__nfet_01v8 ad=0.08775 pd=0.92 as=0.21937 ps=1.325 w=0.65 l=0.15
X2 Y B2 a_109_297# VPB sky130_fd_pr__pfet_01v8_hvt ad=0.305 pd=1.61 as=0.105 ps=1.21 w=1 l=0.15
X3 a_333_297# A3 Y VPB sky130_fd_pr__pfet_01v8_hvt ad=0.245 pd=1.49 as=0.305 ps=1.61 w=1 l=0.15
X4 VGND A1 a_27_47# VNB sky130_fd_pr__nfet_01v8 ad=0.234 pd=2.02 as=0.08775 ps=0.92 w=0.65 l=0.15
X5 a_27_47# B2 Y VNB sky130_fd_pr__nfet_01v8 ad=0.10075 pd=0.96 as=0.10563 ps=0.975 w=0.65 l=0.15
X6 VPWR A1 a_461_297# VPB sky130_fd_pr__pfet_01v8_hvt ad=0.28 pd=2.56 as=0.135 ps=1.27 w=1 l=0.15
X7 a_109_297# B1 VPWR VPB sky130_fd_pr__pfet_01v8_hvt ad=0.105 pd=1.21 as=0.26 ps=2.52 w=1 l=0.15
X8 a_461_297# A2 a_333_297# VPB sky130_fd_pr__pfet_01v8_hvt ad=0.135 pd=1.27 as=0.245 ps=1.49 w=1 l=0.15
X9 Y B1 a_27_47# VNB sky130_fd_pr__nfet_01v8 ad=0.10563 pd=0.975 as=0.169 ps=1.82 w=0.65 l=0.15
.ends

.subckt sky130_fd_sc_hd__clkbuf_4 VGND VPWR A X VPB VNB
X0 VPWR A a_27_47# VPB sky130_fd_pr__pfet_01v8_hvt ad=0.165 pd=1.33 as=0.265 ps=2.53 w=1 l=0.15
X1 VGND a_27_47# X VNB sky130_fd_pr__nfet_01v8 ad=0.1218 pd=1.42 as=0.0588 ps=0.7 w=0.42 l=0.15
X2 VGND a_27_47# X VNB sky130_fd_pr__nfet_01v8 ad=0.0588 pd=0.7 as=0.0588 ps=0.7 w=0.42 l=0.15
X3 X a_27_47# VPWR VPB sky130_fd_pr__pfet_01v8_hvt ad=0.14 pd=1.28 as=0.14 ps=1.28 w=1 l=0.15
X4 X a_27_47# VGND VNB sky130_fd_pr__nfet_01v8 ad=0.0588 pd=0.7 as=0.0588 ps=0.7 w=0.42 l=0.15
X5 VGND A a_27_47# VNB sky130_fd_pr__nfet_01v8 ad=0.07035 pd=0.755 as=0.1113 ps=1.37 w=0.42 l=0.15
X6 VPWR a_27_47# X VPB sky130_fd_pr__pfet_01v8_hvt ad=0.3 pd=2.6 as=0.14 ps=1.28 w=1 l=0.15
X7 X a_27_47# VGND VNB sky130_fd_pr__nfet_01v8 ad=0.0588 pd=0.7 as=0.07035 ps=0.755 w=0.42 l=0.15
X8 X a_27_47# VPWR VPB sky130_fd_pr__pfet_01v8_hvt ad=0.14 pd=1.28 as=0.165 ps=1.33 w=1 l=0.15
X9 VPWR a_27_47# X VPB sky130_fd_pr__pfet_01v8_hvt ad=0.14 pd=1.28 as=0.14 ps=1.28 w=1 l=0.15
.ends

.subckt sky130_fd_sc_hd__buf_2 VPWR VGND X A VPB VNB
X0 VPWR a_27_47# X VPB sky130_fd_pr__pfet_01v8_hvt ad=0.265 pd=2.53 as=0.135 ps=1.27 w=1 l=0.15
X1 X a_27_47# VPWR VPB sky130_fd_pr__pfet_01v8_hvt ad=0.135 pd=1.27 as=0.149 ps=1.325 w=1 l=0.15
X2 VPWR A a_27_47# VPB sky130_fd_pr__pfet_01v8_hvt ad=0.149 pd=1.325 as=0.1664 ps=1.8 w=0.64 l=0.15
X3 X a_27_47# VGND VNB sky130_fd_pr__nfet_01v8 ad=0.08775 pd=0.92 as=0.097 ps=0.975 w=0.65 l=0.15
X4 VGND a_27_47# X VNB sky130_fd_pr__nfet_01v8 ad=0.17225 pd=1.83 as=0.08775 ps=0.92 w=0.65 l=0.15
X5 VGND A a_27_47# VNB sky130_fd_pr__nfet_01v8 ad=0.097 pd=0.975 as=0.1092 ps=1.36 w=0.42 l=0.15
.ends

.subckt sky130_fd_sc_hd__a211oi_2 VPWR VGND VPB VNB A2 A1 Y B1 C1
X0 VGND A2 a_485_47# VNB sky130_fd_pr__nfet_01v8 ad=0.091 pd=0.93 as=0.091 ps=0.93 w=0.65 l=0.15
X1 VPWR A1 a_292_297# VPB sky130_fd_pr__pfet_01v8_hvt ad=0.14 pd=1.28 as=0.14 ps=1.28 w=1 l=0.15
X2 a_37_297# B1 a_292_297# VPB sky130_fd_pr__pfet_01v8_hvt ad=0.265 pd=2.53 as=0.14 ps=1.28 w=1 l=0.15
X3 Y B1 VGND VNB sky130_fd_pr__nfet_01v8 ad=0.091 pd=0.93 as=0.091 ps=0.93 w=0.65 l=0.15
X4 a_485_47# A2 VGND VNB sky130_fd_pr__nfet_01v8 ad=0.17225 pd=1.83 as=0.091 ps=0.93 w=0.65 l=0.15
X5 a_292_297# A2 VPWR VPB sky130_fd_pr__pfet_01v8_hvt ad=0.14 pd=1.28 as=0.14 ps=1.28 w=1 l=0.15
X6 VGND B1 Y VNB sky130_fd_pr__nfet_01v8 ad=0.17225 pd=1.83 as=0.091 ps=0.93 w=0.65 l=0.15
X7 VPWR A2 a_292_297# VPB sky130_fd_pr__pfet_01v8_hvt ad=0.265 pd=2.53 as=0.14 ps=1.28 w=1 l=0.15
X8 a_485_47# A1 Y VNB sky130_fd_pr__nfet_01v8 ad=0.091 pd=0.93 as=0.091 ps=0.93 w=0.65 l=0.15
X9 VGND C1 Y VNB sky130_fd_pr__nfet_01v8 ad=0.091 pd=0.93 as=0.091 ps=0.93 w=0.65 l=0.15
X10 Y C1 VGND VNB sky130_fd_pr__nfet_01v8 ad=0.091 pd=0.93 as=0.17225 ps=1.83 w=0.65 l=0.15
X11 a_37_297# C1 Y VPB sky130_fd_pr__pfet_01v8_hvt ad=0.14 pd=1.28 as=0.14 ps=1.28 w=1 l=0.15
X12 Y A1 a_485_47# VNB sky130_fd_pr__nfet_01v8 ad=0.091 pd=0.93 as=0.17225 ps=1.83 w=0.65 l=0.15
X13 Y C1 a_37_297# VPB sky130_fd_pr__pfet_01v8_hvt ad=0.14 pd=1.28 as=0.265 ps=2.53 w=1 l=0.15
X14 a_292_297# A1 VPWR VPB sky130_fd_pr__pfet_01v8_hvt ad=0.14 pd=1.28 as=0.265 ps=2.53 w=1 l=0.15
X15 a_292_297# B1 a_37_297# VPB sky130_fd_pr__pfet_01v8_hvt ad=0.14 pd=1.28 as=0.14 ps=1.28 w=1 l=0.15
.ends

.subckt sky130_fd_sc_hd__a221o_1 VPWR VGND VPB VNB A1 A2 X B1 B2 C1
X0 a_465_47# A1 a_27_47# VNB sky130_fd_pr__nfet_01v8 ad=0.10725 pd=0.98 as=0.169 ps=1.82 w=0.65 l=0.15
X1 X a_27_47# VPWR VPB sky130_fd_pr__pfet_01v8_hvt ad=0.26 pd=2.52 as=0.1575 ps=1.315 w=1 l=0.15
X2 a_109_297# B1 a_193_297# VPB sky130_fd_pr__pfet_01v8_hvt ad=0.26 pd=2.52 as=0.135 ps=1.27 w=1 l=0.15
X3 a_193_297# B2 a_109_297# VPB sky130_fd_pr__pfet_01v8_hvt ad=0.135 pd=1.27 as=0.135 ps=1.27 w=1 l=0.15
X4 X a_27_47# VGND VNB sky130_fd_pr__nfet_01v8 ad=0.169 pd=1.82 as=0.10238 ps=0.965 w=0.65 l=0.15
X5 a_205_47# B2 VGND VNB sky130_fd_pr__nfet_01v8 ad=0.06825 pd=0.86 as=0.10725 ps=0.98 w=0.65 l=0.15
X6 VPWR A2 a_193_297# VPB sky130_fd_pr__pfet_01v8_hvt ad=0.1575 pd=1.315 as=0.165 ps=1.33 w=1 l=0.15
X7 a_193_297# A1 VPWR VPB sky130_fd_pr__pfet_01v8_hvt ad=0.165 pd=1.33 as=0.26 ps=2.52 w=1 l=0.15
X8 a_27_47# B1 a_205_47# VNB sky130_fd_pr__nfet_01v8 ad=0.169 pd=1.82 as=0.06825 ps=0.86 w=0.65 l=0.15
X9 a_109_297# C1 a_27_47# VPB sky130_fd_pr__pfet_01v8_hvt ad=0.135 pd=1.27 as=0.26 ps=2.52 w=1 l=0.15
X10 VGND C1 a_27_47# VNB sky130_fd_pr__nfet_01v8 ad=0.10725 pd=0.98 as=0.169 ps=1.82 w=0.65 l=0.15
X11 VGND A2 a_465_47# VNB sky130_fd_pr__nfet_01v8 ad=0.10238 pd=0.965 as=0.10725 ps=0.98 w=0.65 l=0.15
.ends

.subckt sky130_fd_sc_hd__nor4_2 VNB VPB VGND VPWR B D Y A C
X0 a_281_297# B a_27_297# VPB sky130_fd_pr__pfet_01v8_hvt ad=0.135 pd=1.27 as=0.135 ps=1.27 w=1 l=0.15
X1 Y B VGND VNB sky130_fd_pr__nfet_01v8 ad=0.08775 pd=0.92 as=0.08775 ps=0.92 w=0.65 l=0.15
X2 a_27_297# A VPWR VPB sky130_fd_pr__pfet_01v8_hvt ad=0.135 pd=1.27 as=0.135 ps=1.27 w=1 l=0.15
X3 a_475_297# D Y VPB sky130_fd_pr__pfet_01v8_hvt ad=0.26 pd=2.52 as=0.135 ps=1.27 w=1 l=0.15
X4 VGND C Y VNB sky130_fd_pr__nfet_01v8 ad=0.08775 pd=0.92 as=0.08775 ps=0.92 w=0.65 l=0.15
X5 Y D a_475_297# VPB sky130_fd_pr__pfet_01v8_hvt ad=0.135 pd=1.27 as=0.135 ps=1.27 w=1 l=0.15
X6 VGND D Y VNB sky130_fd_pr__nfet_01v8 ad=0.169 pd=1.82 as=0.08775 ps=0.92 w=0.65 l=0.15
X7 VGND A Y VNB sky130_fd_pr__nfet_01v8 ad=0.08775 pd=0.92 as=0.08775 ps=0.92 w=0.65 l=0.15
X8 Y A VGND VNB sky130_fd_pr__nfet_01v8 ad=0.08775 pd=0.92 as=0.182 ps=1.86 w=0.65 l=0.15
X9 VGND B Y VNB sky130_fd_pr__nfet_01v8 ad=0.182 pd=1.86 as=0.08775 ps=0.92 w=0.65 l=0.15
X10 Y D VGND VNB sky130_fd_pr__nfet_01v8 ad=0.08775 pd=0.92 as=0.08775 ps=0.92 w=0.65 l=0.15
X11 VPWR A a_27_297# VPB sky130_fd_pr__pfet_01v8_hvt ad=0.135 pd=1.27 as=0.28 ps=2.56 w=1 l=0.15
X12 a_475_297# C a_281_297# VPB sky130_fd_pr__pfet_01v8_hvt ad=0.135 pd=1.27 as=0.135 ps=1.27 w=1 l=0.15
X13 a_281_297# C a_475_297# VPB sky130_fd_pr__pfet_01v8_hvt ad=0.135 pd=1.27 as=0.28 ps=2.56 w=1 l=0.15
X14 a_27_297# B a_281_297# VPB sky130_fd_pr__pfet_01v8_hvt ad=0.28 pd=2.56 as=0.135 ps=1.27 w=1 l=0.15
X15 Y C VGND VNB sky130_fd_pr__nfet_01v8 ad=0.08775 pd=0.92 as=0.182 ps=1.86 w=0.65 l=0.15
.ends

.subckt sky130_fd_sc_hd__a32oi_1 VGND VPWR VPB VNB B2 Y B1 A1 A2 A3
X0 VPWR A3 a_27_297# VPB sky130_fd_pr__pfet_01v8_hvt ad=0.26 pd=2.52 as=0.14 ps=1.28 w=1 l=0.15
X1 VGND A3 a_383_47# VNB sky130_fd_pr__nfet_01v8 ad=0.169 pd=1.82 as=0.10725 ps=0.98 w=0.65 l=0.15
X2 a_309_47# A1 Y VNB sky130_fd_pr__nfet_01v8 ad=0.0715 pd=0.87 as=0.15275 ps=1.12 w=0.65 l=0.15
X3 Y B1 a_109_47# VNB sky130_fd_pr__nfet_01v8 ad=0.15275 pd=1.12 as=0.07475 ps=0.88 w=0.65 l=0.15
X4 a_27_297# B1 Y VPB sky130_fd_pr__pfet_01v8_hvt ad=0.215 pd=1.43 as=0.135 ps=1.27 w=1 l=0.15
X5 a_383_47# A2 a_309_47# VNB sky130_fd_pr__nfet_01v8 ad=0.10725 pd=0.98 as=0.0715 ps=0.87 w=0.65 l=0.15
X6 a_27_297# A2 VPWR VPB sky130_fd_pr__pfet_01v8_hvt ad=0.14 pd=1.28 as=0.135 ps=1.27 w=1 l=0.15
X7 Y B2 a_27_297# VPB sky130_fd_pr__pfet_01v8_hvt ad=0.135 pd=1.27 as=0.26 ps=2.52 w=1 l=0.15
X8 VPWR A1 a_27_297# VPB sky130_fd_pr__pfet_01v8_hvt ad=0.135 pd=1.27 as=0.215 ps=1.43 w=1 l=0.15
X9 a_109_47# B2 VGND VNB sky130_fd_pr__nfet_01v8 ad=0.07475 pd=0.88 as=0.169 ps=1.82 w=0.65 l=0.15
.ends

.subckt sky130_fd_sc_hd__a311o_1 VNB VPB VGND VPWR C1 B1 A1 A2 A3 X
X0 a_75_199# C1 VGND VNB sky130_fd_pr__nfet_01v8 ad=0.169 pd=1.82 as=0.13487 ps=1.065 w=0.65 l=0.15
X1 a_208_47# A3 VGND VNB sky130_fd_pr__nfet_01v8 ad=0.12513 pd=1.035 as=0.11213 ps=0.995 w=0.65 l=0.15
X2 a_315_47# A2 a_208_47# VNB sky130_fd_pr__nfet_01v8 ad=0.169 pd=1.17 as=0.12513 ps=1.035 w=0.65 l=0.15
X3 VGND B1 a_75_199# VNB sky130_fd_pr__nfet_01v8 ad=0.13487 pd=1.065 as=0.10563 ps=0.975 w=0.65 l=0.15
X4 a_75_199# A1 a_315_47# VNB sky130_fd_pr__nfet_01v8 ad=0.10563 pd=0.975 as=0.169 ps=1.17 w=0.65 l=0.15
X5 a_75_199# C1 a_544_297# VPB sky130_fd_pr__pfet_01v8_hvt ad=0.26 pd=2.52 as=0.2075 ps=1.415 w=1 l=0.15
X6 a_544_297# B1 a_201_297# VPB sky130_fd_pr__pfet_01v8_hvt ad=0.2075 pd=1.415 as=0.1625 ps=1.325 w=1 l=0.15
X7 VPWR a_75_199# X VPB sky130_fd_pr__pfet_01v8_hvt ad=0.1425 pd=1.285 as=0.285 ps=2.57 w=1 l=0.15
X8 a_201_297# A3 VPWR VPB sky130_fd_pr__pfet_01v8_hvt ad=0.165 pd=1.33 as=0.1425 ps=1.285 w=1 l=0.15
X9 VPWR A2 a_201_297# VPB sky130_fd_pr__pfet_01v8_hvt ad=0.305 pd=1.61 as=0.165 ps=1.33 w=1 l=0.15
X10 a_201_297# A1 VPWR VPB sky130_fd_pr__pfet_01v8_hvt ad=0.1625 pd=1.325 as=0.305 ps=1.61 w=1 l=0.15
X11 VGND a_75_199# X VNB sky130_fd_pr__nfet_01v8 ad=0.11213 pd=0.995 as=0.169 ps=1.82 w=0.65 l=0.15
.ends

.subckt sky130_fd_sc_hd__a2111oi_0 VNB VPB VPWR VGND D1 C1 A2 A1 B1 Y
X0 Y B1 VGND VNB sky130_fd_pr__nfet_01v8 ad=0.0588 pd=0.7 as=0.0735 ps=0.77 w=0.42 l=0.15
X1 VPWR A1 a_313_369# VPB sky130_fd_pr__pfet_01v8_hvt ad=0.1216 pd=1.02 as=0.0896 ps=0.92 w=0.64 l=0.15
X2 a_427_47# A1 Y VNB sky130_fd_pr__nfet_01v8 ad=0.0441 pd=0.63 as=0.0588 ps=0.7 w=0.42 l=0.15
X3 a_241_369# C1 a_169_369# VPB sky130_fd_pr__pfet_01v8_hvt ad=0.0672 pd=0.85 as=0.0672 ps=0.85 w=0.64 l=0.15
X4 VGND C1 Y VNB sky130_fd_pr__nfet_01v8 ad=0.0735 pd=0.77 as=0.0588 ps=0.7 w=0.42 l=0.15
X5 VGND A2 a_427_47# VNB sky130_fd_pr__nfet_01v8 ad=0.1197 pd=1.41 as=0.0441 ps=0.63 w=0.42 l=0.15
X6 a_169_369# D1 Y VPB sky130_fd_pr__pfet_01v8_hvt ad=0.0672 pd=0.85 as=0.1888 ps=1.87 w=0.64 l=0.15
X7 Y D1 VGND VNB sky130_fd_pr__nfet_01v8 ad=0.0588 pd=0.7 as=0.126 ps=1.44 w=0.42 l=0.15
X8 a_313_369# B1 a_241_369# VPB sky130_fd_pr__pfet_01v8_hvt ad=0.0896 pd=0.92 as=0.0672 ps=0.85 w=0.64 l=0.15
X9 a_313_369# A2 VPWR VPB sky130_fd_pr__pfet_01v8_hvt ad=0.1952 pd=1.89 as=0.1216 ps=1.02 w=0.64 l=0.15
.ends

.subckt sky130_fd_sc_hd__a222oi_1 VNB VPB VPWR VGND C2 C1 B1 A2 A1 Y B2
X0 Y B1 a_393_47# VNB sky130_fd_pr__nfet_01v8 ad=0.1056 pd=0.97 as=0.0672 ps=0.85 w=0.64 l=0.15
X1 VGND A2 a_561_47# VNB sky130_fd_pr__nfet_01v8 ad=0.1664 pd=1.8 as=0.1056 ps=0.97 w=0.64 l=0.15
X2 VGND C2 a_109_47# VNB sky130_fd_pr__nfet_01v8 ad=0.2912 pd=1.55 as=0.0672 ps=0.85 w=0.64 l=0.15
X3 Y C2 a_109_297# VPB sky130_fd_pr__pfet_01v8_hvt ad=0.26 pd=2.52 as=0.135 ps=1.27 w=1 l=0.15
X4 VPWR A1 a_311_297# VPB sky130_fd_pr__pfet_01v8_hvt ad=0.165 pd=1.33 as=0.135 ps=1.27 w=1 l=0.15
X5 a_311_297# A2 VPWR VPB sky130_fd_pr__pfet_01v8_hvt ad=0.26 pd=2.52 as=0.165 ps=1.33 w=1 l=0.15
X6 a_311_297# B1 a_109_297# VPB sky130_fd_pr__pfet_01v8_hvt ad=0.135 pd=1.27 as=0.135 ps=1.27 w=1 l=0.15
X7 a_109_297# B2 a_311_297# VPB sky130_fd_pr__pfet_01v8_hvt ad=0.135 pd=1.27 as=0.26 ps=2.52 w=1 l=0.15
X8 a_109_297# C1 Y VPB sky130_fd_pr__pfet_01v8_hvt ad=0.135 pd=1.27 as=0.26 ps=2.52 w=1 l=0.15
X9 a_393_47# B2 VGND VNB sky130_fd_pr__nfet_01v8 ad=0.0672 pd=0.85 as=0.2912 ps=1.55 w=0.64 l=0.15
X10 a_109_47# C1 Y VNB sky130_fd_pr__nfet_01v8 ad=0.0672 pd=0.85 as=0.1664 ps=1.8 w=0.64 l=0.15
X11 a_561_47# A1 Y VNB sky130_fd_pr__nfet_01v8 ad=0.1056 pd=0.97 as=0.1056 ps=0.97 w=0.64 l=0.15
.ends

.subckt spdif_to_i2s VPWR block_start clk i2s_bclk i2s_sd i2s_ws locked mute pwm_out
+ rst_n spdif_in VGND
X_2037_ VPWR VGND VPWR VGND _2038_/B _1225_/Y _2036_/Y _2600_/D sky130_fd_sc_hd__a21oi_1
X_2106_ VGND VPWR VGND VPWR _2414_/Q _2415_/Q _2114_/C _2102_/D _2106_/Y _2416_/Q
+ sky130_fd_sc_hd__o41ai_1
Xhold340 hold340/X _2507_/Q VPWR VGND VGND VPWR sky130_fd_sc_hd__dlygate4sd3_1
Xhold351 _2560_/D _1980_/Y VPWR VGND VGND VPWR sky130_fd_sc_hd__dlygate4sd3_1
Xhold362 hold362/X _2610_/Q VPWR VGND VGND VPWR sky130_fd_sc_hd__dlygate4sd3_1
Xhold373 hold373/X _2509_/Q VPWR VGND VGND VPWR sky130_fd_sc_hd__dlygate4sd3_1
XFILLER_13_122 VGND VPWR VPWR VGND sky130_fd_sc_hd__decap_12
XFILLER_42_40 VGND VPWR VPWR VGND sky130_fd_sc_hd__decap_12
XPHY_EDGE_ROW_39_Left_110 VPWR VGND VPWR VGND sky130_fd_sc_hd__decap_3
X_1270_ VGND VPWR VGND VPWR _1266_/Y _1472_/A _1274_/A _1269_/Y sky130_fd_sc_hd__o21ai_0
Xwire29 VGND VPWR VPWR VGND wire29/A wire29/X sky130_fd_sc_hd__clkdlybuf4s25_1
XFILLER_51_217 VPWR VGND VPWR VGND sky130_fd_sc_hd__decap_6
X_1606_ VGND VPWR VGND VPWR _1606_/X _2101_/A _2052_/B _2080_/C _1605_/Y sky130_fd_sc_hd__o211a_1
Xfanout138 VGND VPWR VGND VPWR _2424_/Q _2187_/B sky130_fd_sc_hd__clkdlybuf4s50_1
X_2586_ VGND VPWR VPWR VGND clkload8/A _2586_/D load_slew170/X _2586_/Q sky130_fd_sc_hd__dfrtp_1
Xfanout127 VGND VPWR VGND VPWR _2430_/Q _2257_/B sky130_fd_sc_hd__clkdlybuf4s50_1
X_1399_ VPWR VGND VGND VPWR _1442_/C wire36/X _2242_/A _2257_/B sky130_fd_sc_hd__maj3_1
Xfanout105 VGND VPWR VGND VPWR _2485_/Q _2318_/A sky130_fd_sc_hd__clkdlybuf4s50_1
X_1468_ VPWR VGND VPWR VGND _1374_/B _1374_/A _2373_/B _2615_/D sky130_fd_sc_hd__a21oi_1
Xfanout149 VGND VPWR VGND VPWR fanout156/X fanout149/X sky130_fd_sc_hd__clkdlybuf4s50_1
X_1537_ VPWR VGND VGND VPWR _1536_/X _1487_/Y _2632_/Q _1535_/Y _1537_/X sky130_fd_sc_hd__o22a_1
Xfanout116 VGND VPWR VGND VPWR _2273_/A _2272_/A sky130_fd_sc_hd__clkdlybuf4s50_1
XFILLER_27_225 VPWR VGND VPWR VGND sky130_fd_sc_hd__decap_8
XFILLER_12_54 VGND VPWR VPWR VGND sky130_fd_sc_hd__decap_12
XFILLER_53_50 VPWR VGND VPWR VGND sky130_fd_sc_hd__decap_6
X_2440_ VGND VPWR VPWR VGND clkload5/A _2440_/D load_slew162/X _2440_/Q sky130_fd_sc_hd__dfrtp_1
X_1253_ VPWR VGND VGND VPWR _2501_/Q _1814_/A sky130_fd_sc_hd__inv_1
X_1322_ VPWR VGND VGND VPWR _1690_/A _1322_/Y _1322_/B sky130_fd_sc_hd__nand2_1
X_2371_ VGND VPWR VPWR VGND _2440_/Q _2371_/X _2439_/Q sky130_fd_sc_hd__xor2_1
XFILLER_59_103 VPWR VGND VPWR VGND sky130_fd_sc_hd__decap_8
X_2569_ VGND VPWR VPWR VGND clkload6/A _2569_/D load_slew147/X _2569_/Q sky130_fd_sc_hd__dfrtp_1
XFILLER_23_53 VPWR VGND VPWR VGND sky130_fd_sc_hd__decap_3
XFILLER_0_57 VPWR VGND VPWR VGND sky130_fd_sc_hd__decap_8
X_1871_ VGND VPWR VGND VPWR _1870_/Y _1933_/B _2523_/D _1869_/Y sky130_fd_sc_hd__o21ai_0
X_1940_ VGND VPWR VGND VPWR _1939_/Y _1942_/B _2546_/D _1938_/Y sky130_fd_sc_hd__o21ai_0
X_2423_ VPWR VGND VPWR VGND _2423_/Q fanout187/X _2423_/D _2633_/CLK sky130_fd_sc_hd__dfstp_2
XPHY_EDGE_ROW_24_Left_95 VPWR VGND VPWR VGND sky130_fd_sc_hd__decap_3
X_1305_ VGND VPWR _1305_/B _1305_/Y _1305_/A VPWR VGND sky130_fd_sc_hd__xnor2_1
X_2285_ VPWR VGND VPWR VGND _2431_/D _2136_/Y _2271_/Y _2284_/Y hold339/X _2136_/A
+ sky130_fd_sc_hd__o32a_1
X_2354_ VGND VPWR VPWR VGND _2348_/A _2350_/B _2348_/B _2356_/B sky130_fd_sc_hd__a21boi_0
X_1236_ VPWR VGND VGND VPWR _2448_/Q _1236_/Y sky130_fd_sc_hd__inv_1
XFILLER_20_253 VGND VPWR VPWR VGND sky130_fd_sc_hd__decap_12
XFILLER_70_197 VPWR VGND VPWR VGND sky130_fd_sc_hd__decap_3
XFILLER_11_264 VGND VPWR VPWR VGND sky130_fd_sc_hd__decap_12
XFILLER_59_93 VPWR VGND VPWR VGND sky130_fd_sc_hd__decap_3
X_2070_ VGND VPWR VPWR VGND _2402_/D hold359/X _2074_/S _2460_/Q sky130_fd_sc_hd__mux2_1
X_1785_ VPWR VGND VGND VPWR _1785_/A _2050_/B _1785_/Y sky130_fd_sc_hd__nor2_1
XFILLER_61_197 VGND VPWR VPWR VGND sky130_fd_sc_hd__decap_12
X_1854_ VPWR VGND VGND VPWR _2517_/Q _1854_/Y _2591_/Q _1932_/S sky130_fd_sc_hd__mux2i_1
X_1923_ VPWR VGND VGND VPWR _2540_/Q _1923_/Y _2566_/Q _1947_/S sky130_fd_sc_hd__mux2i_1
X_2406_ VGND VPWR VPWR VGND _2607_/CLK _2406_/D fanout176/X _2406_/Q sky130_fd_sc_hd__dfrtp_1
Xfanout7 VGND VPWR VGND VPWR _2076_/S _2054_/S sky130_fd_sc_hd__clkdlybuf4s50_1
X_2199_ VPWR VGND VGND VPWR _2477_/Q _2199_/Y _2200_/B sky130_fd_sc_hd__nand2_1
X_2268_ VPWR VGND VPWR VGND _2256_/Y _2173_/A _1466_/B _2268_/Y sky130_fd_sc_hd__a21oi_1
X_2337_ VGND VPWR VGND VPWR _2320_/Y _2321_/A _2339_/B _2323_/B sky130_fd_sc_hd__o21ai_0
X_1219_ VPWR VGND VGND VPWR _2409_/Q _1219_/Y sky130_fd_sc_hd__inv_1
XFILLER_4_249 VPWR VGND VPWR VGND sky130_fd_sc_hd__decap_3
XFILLER_20_43 VGND VPWR VPWR VGND sky130_fd_sc_hd__decap_12
XFILLER_29_30 VPWR VGND VPWR VGND sky130_fd_sc_hd__decap_6
X_1570_ VPWR VGND VGND VPWR _1977_/B _1570_/B _1573_/C _2619_/D sky130_fd_sc_hd__nor3_1
X_2053_ VGND VPWR VPWR VGND _2385_/D hold355/X _2054_/S _2443_/Q sky130_fd_sc_hd__mux2_1
X_2122_ VPWR VGND VGND VPWR _2122_/A _2122_/B _2130_/C sky130_fd_sc_hd__nor2_1
XFILLER_13_3 VGND VPWR VPWR VGND sky130_fd_sc_hd__decap_4
X_1768_ VPWR VGND VGND VPWR _2119_/C _1768_/B _1770_/A sky130_fd_sc_hd__nor2_1
X_1837_ VPWR VGND VGND VPWR _1837_/A _1837_/Y _1909_/B sky130_fd_sc_hd__nand2_1
X_1906_ VPWR VGND VGND VPWR _1906_/A _1906_/Y _1909_/B sky130_fd_sc_hd__nand2_1
X_1699_ VPWR VGND VGND VPWR _2289_/A _1700_/B _1699_/B sky130_fd_sc_hd__nand2_1
XPHY_EDGE_ROW_11_Left_82 VPWR VGND VPWR VGND sky130_fd_sc_hd__decap_3
XFILLER_63_237 VGND VPWR VPWR VGND sky130_fd_sc_hd__decap_4
XFILLER_48_234 VPWR VGND VPWR VGND sky130_fd_sc_hd__decap_8
XFILLER_16_120 VGND VPWR VPWR VGND sky130_fd_sc_hd__decap_12
X_1622_ VPWR VGND VGND VPWR _1230_/Y _2454_/D _1621_/Y _1624_/S sky130_fd_sc_hd__mux2i_1
X_1484_ VPWR VGND VGND VPWR _1484_/A _1530_/B _1484_/B sky130_fd_sc_hd__nand2_1
X_1553_ VPWR VGND VGND VPWR _1556_/B _2483_/Q _2484_/Q _2485_/Q _2332_/A sky130_fd_sc_hd__nor4_1
X_2036_ VPWR VGND VGND VPWR _2036_/A _2038_/B _2036_/Y sky130_fd_sc_hd__nor2_1
X_2105_ VPWR VGND VGND VPWR _2105_/A _2108_/B _2105_/Y _2108_/C sky130_fd_sc_hd__nand3_1
Xhold374 hold374/X _2506_/Q VPWR VGND VGND VPWR sky130_fd_sc_hd__dlygate4sd3_1
Xhold352 _1804_/A _2500_/Q VPWR VGND VGND VPWR sky130_fd_sc_hd__dlygate4sd3_1
Xhold330 _1822_/A _2504_/Q VPWR VGND VGND VPWR sky130_fd_sc_hd__dlygate4sd3_1
Xhold341 _1708_/A _2487_/Q VPWR VGND VGND VPWR sky130_fd_sc_hd__dlygate4sd3_1
Xhold363 hold363/X _2401_/Q VPWR VGND VGND VPWR sky130_fd_sc_hd__dlygate4sd3_1
XFILLER_13_134 VPWR VGND VPWR VGND sky130_fd_sc_hd__decap_6
XFILLER_42_52 VPWR VGND VPWR VGND sky130_fd_sc_hd__decap_8
XFILLER_51_207 VPWR VGND VPWR VGND sky130_fd_sc_hd__decap_6
X_2585_ VGND VPWR VPWR VGND _2606_/CLK _2585_/D fanout173/X _2585_/Q sky130_fd_sc_hd__dfrtp_1
X_1536_ VPWR VGND VPWR VGND _1488_/Y _2632_/Q _1487_/Y _1536_/X _2631_/Q sky130_fd_sc_hd__a22o_1
X_1605_ VPWR VGND VGND VPWR _2082_/A _2412_/Q _1605_/Y _2413_/Q sky130_fd_sc_hd__nand3_1
Xfanout139 VGND VPWR VGND VPWR _2424_/Q _1431_/B sky130_fd_sc_hd__clkdlybuf4s50_1
Xfanout128 VGND VPWR VGND VPWR _2429_/Q _2242_/B sky130_fd_sc_hd__clkdlybuf4s50_1
X_1398_ VGND VPWR VPWR VGND _2242_/A _1422_/B _2255_/A sky130_fd_sc_hd__xor2_1
Xfanout106 VGND VPWR VGND VPWR _2482_/Q _2274_/A sky130_fd_sc_hd__clkdlybuf4s50_1
X_1467_ VPWR VGND VGND VPWR _1467_/A _2373_/B _1467_/B sky130_fd_sc_hd__nand2_1
Xfanout117 VGND VPWR VGND VPWR _2316_/A _2273_/A sky130_fd_sc_hd__clkdlybuf4s50_1
X_2019_ VPWR VGND VPWR VGND _2034_/B _1234_/Y _2018_/Y _2591_/D sky130_fd_sc_hd__a21oi_1
XFILLER_27_237 VGND VPWR VPWR VGND sky130_fd_sc_hd__decap_12
XFILLER_27_259 VGND VPWR VPWR VGND sky130_fd_sc_hd__decap_12
XFILLER_12_66 VGND VPWR VPWR VGND sky130_fd_sc_hd__decap_4
Xhold193 _2612_/D _2616_/Q VPWR VGND VGND VPWR sky130_fd_sc_hd__dlygate4sd3_1
X_1252_ VPWR VGND VGND VPWR _2500_/Q _1813_/A sky130_fd_sc_hd__inv_1
X_1321_ VPWR VGND VGND VPWR _1692_/A _1321_/B _1321_/Y sky130_fd_sc_hd__nor2_1
X_2370_ VPWR VGND VPWR VGND _2369_/Y _1467_/A _2368_/Y _2439_/D _2439_/Q sky130_fd_sc_hd__a22o_1
XFILLER_17_281 VPWR VGND VPWR VGND sky130_fd_sc_hd__decap_8
XFILLER_24_229 VGND VPWR VPWR VGND sky130_fd_sc_hd__decap_12
X_2499_ VGND VPWR VPWR VGND _2634_/CLK _2499_/D fanout182/X _2499_/Q sky130_fd_sc_hd__dfrtp_1
XPHY_EDGE_ROW_58_Left_129 VPWR VGND VPWR VGND sky130_fd_sc_hd__decap_3
X_1519_ VPWR VGND VGND VPWR _1519_/A _1523_/A _1519_/Y sky130_fd_sc_hd__nor2_1
X_2568_ VGND VPWR VPWR VGND _2592_/CLK _2568_/D load_slew147/X _2568_/Q sky130_fd_sc_hd__dfrtp_1
XPHY_EDGE_ROW_12_Right_12 VPWR VGND VPWR VGND sky130_fd_sc_hd__decap_3
XPHY_EDGE_ROW_21_Right_21 VPWR VGND VPWR VGND sky130_fd_sc_hd__decap_3
XPHY_EDGE_ROW_67_Left_138 VPWR VGND VPWR VGND sky130_fd_sc_hd__decap_3
XPHY_EDGE_ROW_30_Right_30 VPWR VGND VPWR VGND sky130_fd_sc_hd__decap_3
X_1870_ VPWR VGND VGND VPWR _1870_/A _1870_/Y _1933_/B sky130_fd_sc_hd__nand2_1
XFILLER_43_3 VPWR VGND VPWR VGND sky130_fd_sc_hd__decap_6
X_2353_ VPWR VGND VPWR VGND _2436_/D fanout3/X _2345_/Y _2352_/Y _2351_/A _2327_/B
+ sky130_fd_sc_hd__o32a_1
X_2422_ VGND VPWR VPWR VGND clkload5/A _2422_/D load_slew162/X locked sky130_fd_sc_hd__dfrtp_2
X_1304_ VGND VPWR _1295_/A _1305_/B _1303_/Y _1289_/A _1289_/B _1289_/C VPWR VGND
+ sky130_fd_sc_hd__a41oi_1
X_2284_ VPWR VGND VPWR VGND _2284_/Y _2173_/A _2283_/Y _2283_/B _2282_/X sky130_fd_sc_hd__a211oi_1
X_1235_ VPWR VGND VGND VPWR _2449_/Q _1235_/Y sky130_fd_sc_hd__inv_1
X_1999_ VGND VPWR VPWR VGND _2579_/D _2404_/Q _1999_/S hold323/X sky130_fd_sc_hd__mux2_1
XFILLER_20_265 VGND VPWR VPWR VGND sky130_fd_sc_hd__decap_4
XFILLER_70_121 VPWR VGND VPWR VGND sky130_fd_sc_hd__decap_8
XFILLER_70_176 VGND VPWR VPWR VGND sky130_fd_sc_hd__decap_12
XFILLER_11_276 VGND VPWR VPWR VGND sky130_fd_sc_hd__decap_4
Xload_slew64 VPWR VGND _1932_/S _1917_/S VPWR VGND sky130_fd_sc_hd__buf_4
X_1922_ VGND VPWR VGND VPWR _1921_/Y _1924_/B _1922_/Y _1920_/Y sky130_fd_sc_hd__o21ai_0
X_1784_ VPWR VGND VPWR VGND _1782_/Y _2050_/B _1783_/Y _2492_/D sky130_fd_sc_hd__a21oi_1
X_1853_ VGND VPWR VGND VPWR _1852_/Y _1945_/B _2517_/D _1851_/Y sky130_fd_sc_hd__o21ai_0
X_2405_ VGND VPWR VPWR VGND clkload9/A _2405_/D load_slew177/X _2405_/Q sky130_fd_sc_hd__dfrtp_1
X_2336_ VGND VPWR VPWR VGND _2336_/A _2339_/A _2336_/B sky130_fd_sc_hd__xor2_1
X_2198_ VGND VPWR _2198_/B _2200_/B _2198_/A VPWR VGND sky130_fd_sc_hd__xnor2_1
X_2267_ VGND VPWR VGND VPWR _2266_/Y _2255_/A _2267_/Y _2283_/B sky130_fd_sc_hd__o21ai_0
X_1218_ VPWR VGND VGND VPWR _2410_/Q _1218_/Y sky130_fd_sc_hd__inv_1
XFILLER_20_55 VPWR VGND VPWR VGND sky130_fd_sc_hd__decap_8
XFILLER_43_121 VPWR VGND VPWR VGND sky130_fd_sc_hd__decap_3
X_2052_ VPWR VGND VGND VPWR _2441_/Q _2052_/B _2052_/Y _2052_/C sky130_fd_sc_hd__nand3_1
X_2121_ VPWR VGND VGND VPWR _2121_/A _2121_/B _2122_/B _2121_/C sky130_fd_sc_hd__nand3_1
X_1905_ VPWR VGND VGND VPWR _2534_/Q _1905_/Y _2560_/Q _1971_/S sky130_fd_sc_hd__mux2i_1
X_1767_ VGND VPWR VPWR VGND _1768_/B _2405_/Q _2463_/Q sky130_fd_sc_hd__and2_0
X_1836_ VPWR VGND VGND VPWR _2511_/Q _1836_/Y _2585_/Q _1902_/S sky130_fd_sc_hd__mux2i_1
XPHY_EDGE_ROW_6_Right_6 VPWR VGND VPWR VGND sky130_fd_sc_hd__decap_3
X_1698_ VPWR VGND VPWR VGND _1697_/Y _1672_/C _2096_/A _2482_/D sky130_fd_sc_hd__a21oi_1
X_2319_ VPWR VGND VPWR VGND _2321_/A _2318_/Y _2317_/X _2304_/Y _2306_/Y sky130_fd_sc_hd__a211oi_1
XFILLER_15_44 VPWR VGND VPWR VGND sky130_fd_sc_hd__decap_3
XFILLER_0_253 VGND VPWR VPWR VGND sky130_fd_sc_hd__decap_12
XFILLER_56_51 VGND VPWR VPWR VGND sky130_fd_sc_hd__decap_4
XPHY_EDGE_ROW_59_Right_59 VPWR VGND VPWR VGND sky130_fd_sc_hd__decap_3
XFILLER_31_113 VPWR VGND VPWR VGND sky130_fd_sc_hd__decap_6
XFILLER_16_187 VPWR VGND VPWR VGND sky130_fd_sc_hd__decap_8
X_1621_ VPWR VGND VGND VPWR _1627_/A _1621_/Y _2455_/Q sky130_fd_sc_hd__nand2_1
X_1552_ VPWR VGND VGND VPWR _1556_/A _1690_/A _2480_/Q _2481_/Q _2274_/A sky130_fd_sc_hd__nor4_1
XPHY_EDGE_ROW_68_Right_68 VPWR VGND VPWR VGND sky130_fd_sc_hd__decap_3
X_1483_ VPWR VGND VGND VPWR _1485_/A _1530_/A _1523_/B sky130_fd_sc_hd__nand2_1
X_2104_ VPWR VGND VPWR VGND _2103_/Y _2102_/X _2110_/B1 _2415_/D sky130_fd_sc_hd__a21oi_1
X_2035_ VPWR VGND VPWR VGND _2034_/B _1226_/Y _2034_/Y _2599_/D sky130_fd_sc_hd__a21oi_1
X_1819_ VGND VPWR _1828_/B _2507_/Q _2506_/Q _2633_/Q VPWR VGND sky130_fd_sc_hd__and3_1
Xhold342 _1825_/B _2633_/Q VPWR VGND VGND VPWR sky130_fd_sc_hd__dlygate4sd3_1
Xhold320 hold320/X _2583_/Q VPWR VGND VGND VPWR sky130_fd_sc_hd__dlygate4sd3_1
Xhold375 hold375/X _2604_/Q VPWR VGND VGND VPWR sky130_fd_sc_hd__dlygate4sd3_1
Xhold364 _2401_/D _2069_/X VPWR VGND VGND VPWR sky130_fd_sc_hd__dlygate4sd3_1
Xhold353 hold353/X _2420_/Q VPWR VGND VGND VPWR sky130_fd_sc_hd__dlygate4sd3_1
Xhold331 hold331/X _2573_/Q VPWR VGND VGND VPWR sky130_fd_sc_hd__dlygate4sd3_1
XFILLER_44_282 VPWR VGND VPWR VGND sky130_fd_sc_hd__decap_6
X_2584_ VGND VPWR VPWR VGND _2606_/CLK _2584_/D fanout169/X _2584_/Q sky130_fd_sc_hd__dfrtp_1
Xfanout129 VGND VPWR VGND VPWR _2429_/Q _2198_/A sky130_fd_sc_hd__clkdlybuf4s50_1
X_1535_ VPWR VGND VPWR VGND _1534_/Y _1532_/Y _1533_/Y _1535_/Y sky130_fd_sc_hd__a21oi_1
Xfanout118 VGND VPWR VGND VPWR _2434_/Q _2316_/A sky130_fd_sc_hd__clkdlybuf4s50_1
X_1604_ VGND VPWR VGND VPWR _1543_/Y _2609_/Q _2375_/C _1561_/B sky130_fd_sc_hd__o21ai_0
Xfanout107 VGND VPWR VGND VPWR _2479_/Q _1690_/A sky130_fd_sc_hd__clkdlybuf4s50_1
X_1397_ VPWR VGND _1383_/Y _1396_/A _1396_/B wire36/A _1382_/Y VPWR VGND sky130_fd_sc_hd__o31ai_1
X_1466_ VPWR VGND VGND VPWR _2440_/Q _1466_/B _1467_/B sky130_fd_sc_hd__nor2_1
XFILLER_42_208 VGND VPWR VPWR VGND sky130_fd_sc_hd__decap_12
X_2018_ VPWR VGND VGND VPWR _2018_/A _2034_/B _2018_/Y sky130_fd_sc_hd__nor2_1
Xhold194 _2613_/D _2612_/Q VPWR VGND VGND VPWR sky130_fd_sc_hd__dlygate4sd3_1
X_1320_ VGND VPWR VPWR VGND _1340_/C _1321_/B _1320_/B sky130_fd_sc_hd__xor2_1
X_1251_ VPWR VGND VGND VPWR _2499_/Q _1812_/A sky130_fd_sc_hd__inv_1
XFILLER_32_241 VPWR VGND VPWR VGND sky130_fd_sc_hd__decap_6
X_2498_ VGND VPWR VPWR VGND _2634_/CLK _2498_/D fanout182/X _2498_/Q sky130_fd_sc_hd__dfrtp_1
X_1518_ VPWR VGND _2625_/Q _1523_/A _1515_/Y _1518_/Y _1517_/Y VPWR VGND sky130_fd_sc_hd__o31ai_1
X_2567_ VGND VPWR VPWR VGND _2592_/CLK _2567_/D fanout148/X _2567_/Q sky130_fd_sc_hd__dfrtp_1
X_1449_ VPWR VGND VGND VPWR _2484_/Q _1416_/Y _1419_/Y _1448_/Y _1449_/Y sky130_fd_sc_hd__o22ai_1
XFILLER_3_3 VPWR VGND VPWR VGND sky130_fd_sc_hd__decap_8
XFILLER_2_134 VPWR VGND VPWR VGND sky130_fd_sc_hd__decap_6
XFILLER_0_15 VGND VPWR VPWR VGND sky130_fd_sc_hd__decap_12
X_1303_ VPWR VGND VGND VPWR _1303_/A _1393_/A _1303_/Y sky130_fd_sc_hd__nor2_1
X_2283_ VPWR VGND VGND VPWR _2283_/A _2283_/B _2283_/Y sky130_fd_sc_hd__nor2_1
X_2421_ VPWR VGND VPWR VGND _2421_/Q _2429_/SET_B _2421_/D _2606_/CLK sky130_fd_sc_hd__dfstp_2
X_2352_ VPWR VGND VPWR VGND _2352_/Y _1557_/A _2351_/Y _2351_/B _2350_/X sky130_fd_sc_hd__a211oi_1
X_1234_ VPWR VGND VGND VPWR _2450_/Q _1234_/Y sky130_fd_sc_hd__inv_1
X_2619_ VGND VPWR VPWR VGND _2633_/CLK _2619_/D fanout187/A _2619_/Q sky130_fd_sc_hd__dfrtp_1
X_1998_ VGND VPWR VPWR VGND _1998_/X _2403_/Q _1999_/S hold271/X sky130_fd_sc_hd__mux2_1
XFILLER_70_188 VPWR VGND VPWR VGND sky130_fd_sc_hd__decap_8
XFILLER_38_108 VPWR VGND VPWR VGND sky130_fd_sc_hd__decap_6
XFILLER_61_177 VGND VPWR VPWR VGND sky130_fd_sc_hd__decap_4
X_1852_ VPWR VGND VGND VPWR _1852_/A _1852_/Y _1945_/B sky130_fd_sc_hd__nand2_1
X_1921_ VPWR VGND VGND VPWR _1921_/A _1921_/Y _1948_/B sky130_fd_sc_hd__nand2_1
X_1783_ VPWR VGND VGND VPWR _1783_/A _2050_/B _1783_/Y sky130_fd_sc_hd__nor2_1
Xfanout9 VGND VPWR VGND VPWR _2052_/Y _2076_/S sky130_fd_sc_hd__clkdlybuf4s50_1
X_2404_ VGND VPWR VPWR VGND _2634_/CLK _2404_/D load_slew177/X _2404_/Q sky130_fd_sc_hd__dfrtp_1
X_2266_ VPWR VGND VPWR VGND _2265_/Y _2283_/B _2173_/A _2266_/Y sky130_fd_sc_hd__a21oi_1
X_2335_ VPWR VGND VGND VPWR _2336_/A _2349_/A _2336_/B sky130_fd_sc_hd__nand2_1
X_2197_ VGND VPWR VPWR VGND _2197_/X _2474_/Q _2286_/S _2198_/B sky130_fd_sc_hd__mux2_1
X_1217_ VPWR VGND VGND VPWR _2082_/A _2101_/A sky130_fd_sc_hd__inv_1
XFILLER_28_141 VPWR VGND VPWR VGND sky130_fd_sc_hd__decap_6
XFILLER_45_42 VPWR VGND VPWR VGND sky130_fd_sc_hd__decap_6
X_2120_ VPWR VGND VGND VPWR _2121_/C _2398_/Q _2456_/Q _2399_/Q _2457_/Q sky130_fd_sc_hd__nor4_1
XFILLER_66_247 VGND VPWR VPWR VGND sky130_fd_sc_hd__decap_4
X_2051_ VPWR VGND VPWR VGND _2050_/B _1247_/Y _2050_/Y _2607_/D sky130_fd_sc_hd__a21oi_1
X_1835_ VGND VPWR VPWR VGND _1835_/X _1831_/A _2584_/Q _2504_/Q _1969_/B hold251/X
+ sky130_fd_sc_hd__a32o_1
X_1904_ VGND VPWR VGND VPWR _1903_/Y _1909_/B _1904_/Y _1902_/Y sky130_fd_sc_hd__o21ai_0
X_1766_ VPWR VGND VGND VPWR _2463_/Q _2405_/Q _2119_/C sky130_fd_sc_hd__nor2_1
X_1697_ VGND VPWR _1697_/B _1697_/Y _2274_/A VPWR VGND sky130_fd_sc_hd__xnor2_1
XFILLER_57_225 VPWR VGND VPWR VGND sky130_fd_sc_hd__decap_8
X_2249_ _2249_/Y _2248_/X _2234_/X _2235_/A _2229_/B _2229_/A VPWR VGND VGND VPWR
+ sky130_fd_sc_hd__o311ai_1
X_2318_ VPWR VGND VGND VPWR _2318_/A _2318_/B _2318_/Y sky130_fd_sc_hd__nor2_1
XFILLER_0_265 VGND VPWR VPWR VGND sky130_fd_sc_hd__decap_12
XFILLER_56_85 VPWR VGND VPWR VGND sky130_fd_sc_hd__decap_8
XFILLER_56_63 VPWR VGND VPWR VGND sky130_fd_sc_hd__decap_8
X_1482_ VPWR VGND VGND VPWR _1486_/D _1523_/A _2242_/A _1482_/Y sky130_fd_sc_hd__nor3_1
X_1551_ VPWR VGND VGND VPWR _2114_/B _2420_/Q _2419_/Q _1560_/B sky130_fd_sc_hd__nor3_1
X_1620_ VPWR VGND VGND VPWR _1231_/Y _2453_/D _1619_/Y _1624_/S sky130_fd_sc_hd__mux2i_1
XFILLER_39_225 VGND VPWR VPWR VGND sky130_fd_sc_hd__decap_4
X_2103_ VPWR VGND _2414_/Q _2114_/C _2102_/D _2103_/Y _2415_/Q VPWR VGND sky130_fd_sc_hd__o31ai_1
X_2034_ VPWR VGND VGND VPWR _2034_/A _2034_/B _2034_/Y sky130_fd_sc_hd__nor2_1
X_1818_ VPWR VGND VGND VPWR _2510_/Q _1833_/A _2509_/Q sky130_fd_sc_hd__nand2_1
Xhold310 _2010_/A _2587_/Q VPWR VGND VGND VPWR sky130_fd_sc_hd__dlygate4sd3_1
Xhold332 _1806_/A _2501_/Q VPWR VGND VGND VPWR sky130_fd_sc_hd__dlygate4sd3_1
Xhold321 _1785_/A _2493_/Q VPWR VGND VGND VPWR sky130_fd_sc_hd__dlygate4sd3_1
Xhold343 hold343/X _2498_/Q VPWR VGND VGND VPWR sky130_fd_sc_hd__dlygate4sd3_1
X_1749_ VGND VPWR _1749_/B _1749_/Y _1749_/A VPWR VGND sky130_fd_sc_hd__xnor2_1
Xhold365 hold365/X _2386_/Q VPWR VGND VGND VPWR sky130_fd_sc_hd__dlygate4sd3_1
Xhold376 hold376/X _2524_/Q VPWR VGND VGND VPWR sky130_fd_sc_hd__dlygate4sd3_1
Xhold354 hold354/X _2632_/Q VPWR VGND VGND VPWR sky130_fd_sc_hd__dlygate4sd3_1
XFILLER_53_261 VPWR VGND VPWR VGND sky130_fd_sc_hd__decap_6
XFILLER_13_158 VPWR VGND VPWR VGND sky130_fd_sc_hd__decap_8
XFILLER_13_169 VGND VPWR VPWR VGND sky130_fd_sc_hd__decap_4
XFILLER_67_51 VGND VPWR VPWR VGND sky130_fd_sc_hd__decap_4
XFILLER_66_3 VPWR VGND VPWR VGND sky130_fd_sc_hd__decap_8
X_2583_ VGND VPWR VPWR VGND _2607_/CLK _2583_/D fanout182/X _2583_/Q sky130_fd_sc_hd__dfrtp_1
X_1534_ VPWR VGND VPWR VGND _2629_/Q _1530_/Y _1534_/Y _2630_/Q _1490_/X sky130_fd_sc_hd__a22oi_1
Xfanout119 VGND VPWR VGND VPWR _2257_/A _1486_/A sky130_fd_sc_hd__clkdlybuf4s50_1
Xfanout108 VGND VPWR VGND VPWR _2438_/Q _2331_/B sky130_fd_sc_hd__clkdlybuf4s50_1
X_1465_ VPWR VGND VGND VPWR _2609_/Q _2439_/Q _1467_/A sky130_fd_sc_hd__nor2b_1
X_1603_ VPWR VGND VGND VPWR _1603_/A _1603_/B _2632_/D sky130_fd_sc_hd__nor2_1
X_1396_ VPWR VGND VGND VPWR _1396_/A _1396_/B _1423_/B sky130_fd_sc_hd__nor2_1
X_2017_ VPWR VGND VPWR VGND _2032_/B _1235_/Y _2016_/Y _2590_/D sky130_fd_sc_hd__a21oi_1
Xhold195 _1951_/A _2550_/Q VPWR VGND VGND VPWR sky130_fd_sc_hd__dlygate4sd3_1
XFILLER_53_20 VGND VPWR VPWR VGND sky130_fd_sc_hd__decap_4
XFILLER_26_261 VPWR VGND VPWR VGND sky130_fd_sc_hd__decap_6
X_1250_ VPWR VGND VGND VPWR _2498_/Q _1811_/A sky130_fd_sc_hd__inv_1
XFILLER_17_261 VPWR VGND VPWR VGND sky130_fd_sc_hd__decap_8
X_2497_ VGND VPWR VPWR VGND _2634_/CLK _2497_/D load_slew175/X _2497_/Q sky130_fd_sc_hd__dfrtp_1
X_1517_ VGND VPWR VPWR VGND _1514_/Y _1513_/Y _1511_/Y _1517_/Y _1516_/Y sky130_fd_sc_hd__a31oi_1
X_1448_ VGND VPWR VPWR VGND _1448_/Y _1444_/Y _1447_/Y _2289_/A _1419_/B _1446_/Y
+ sky130_fd_sc_hd__a221oi_1
X_2566_ VGND VPWR VPWR VGND clkload2/A _2566_/D load_slew154/X _2566_/Q sky130_fd_sc_hd__dfrtp_1
X_1379_ VPWR VGND VGND VPWR _1484_/A _1379_/Y _2257_/A sky130_fd_sc_hd__nand2_1
XFILLER_23_89 VPWR VGND VPWR VGND sky130_fd_sc_hd__decap_3
XFILLER_23_242 VGND VPWR VPWR VGND sky130_fd_sc_hd__decap_4
XFILLER_14_286 VPWR VGND VPWR VGND sky130_fd_sc_hd__decap_3
Xfanout90 VGND VPWR VGND VPWR _2042_/B _2010_/B sky130_fd_sc_hd__clkdlybuf4s50_1
X_2420_ VPWR VGND VPWR VGND _2420_/Q _2437_/SET_B _2420_/D _2592_/CLK sky130_fd_sc_hd__dfstp_2
X_1302_ VPWR VGND VGND VPWR _2241_/B _1302_/Y _2212_/B sky130_fd_sc_hd__nand2_1
X_2282_ VGND VPWR VPWR VGND _2282_/A _2282_/X _2282_/B sky130_fd_sc_hd__xor2_1
X_2351_ VPWR VGND VGND VPWR _2351_/A _2351_/B _2351_/Y sky130_fd_sc_hd__nor2_1
X_1233_ VPWR VGND VGND VPWR _2451_/Q _1233_/Y sky130_fd_sc_hd__inv_1
XFILLER_29_3 VPWR VGND VPWR VGND sky130_fd_sc_hd__decap_6
X_1997_ VGND VPWR VPWR VGND _1997_/X _2402_/Q _2038_/B hold259/X sky130_fd_sc_hd__mux2_1
X_2618_ VGND VPWR VPWR VGND _2633_/CLK _2618_/D fanout187/X _2618_/Q sky130_fd_sc_hd__dfrtp_1
X_2549_ VGND VPWR VPWR VGND clkload1/A _2549_/D load_slew152/X _2549_/Q sky130_fd_sc_hd__dfrtp_1
XFILLER_18_23 VGND VPWR VPWR VGND sky130_fd_sc_hd__decap_4
XFILLER_11_245 VGND VPWR VPWR VGND sky130_fd_sc_hd__decap_4
XFILLER_59_85 VPWR VGND VPWR VGND sky130_fd_sc_hd__decap_8
XFILLER_59_52 VGND VPWR VPWR VGND sky130_fd_sc_hd__decap_4
XFILLER_46_197 VGND VPWR VPWR VGND sky130_fd_sc_hd__decap_4
Xload_slew66 VPWR VGND _1884_/S _1956_/S VPWR VGND sky130_fd_sc_hd__buf_4
Xload_slew11 VPWR VGND _1628_/S _1624_/S VPWR VGND sky130_fd_sc_hd__buf_4
XPHY_EDGE_ROW_28_Left_99 VPWR VGND VPWR VGND sky130_fd_sc_hd__decap_3
X_1851_ VPWR VGND VGND VPWR _2516_/Q _1851_/Y hold380/X _1932_/S sky130_fd_sc_hd__mux2i_1
X_1920_ VPWR VGND VGND VPWR _2539_/Q _1920_/Y _2565_/Q _1947_/S sky130_fd_sc_hd__mux2i_1
X_1782_ VGND VPWR _1788_/C _1782_/Y _1782_/A VPWR VGND sky130_fd_sc_hd__xnor2_1
X_2403_ VGND VPWR VPWR VGND clkload9/A _2403_/D load_slew177/X _2403_/Q sky130_fd_sc_hd__dfrtp_1
X_1216_ VPWR VGND VGND VPWR _2471_/Q _1216_/Y sky130_fd_sc_hd__inv_1
X_2196_ VPWR VGND VGND VPWR _2198_/B _2196_/B _2196_/Y sky130_fd_sc_hd__nor2_1
X_2265_ VGND VPWR _2265_/B _2265_/Y _2265_/A VPWR VGND sky130_fd_sc_hd__xnor2_1
X_2334_ VPWR VGND VPWR VGND _1202_/Y _2316_/A _2317_/X _2336_/B sky130_fd_sc_hd__a21o_1
XFILLER_20_68 VPWR VGND VPWR VGND sky130_fd_sc_hd__decap_8
XFILLER_28_197 VGND VPWR VPWR VGND sky130_fd_sc_hd__decap_12
X_2050_ VPWR VGND VGND VPWR _2050_/A _2050_/B _2050_/Y sky130_fd_sc_hd__nor2_1
XFILLER_34_134 VPWR VGND VPWR VGND sky130_fd_sc_hd__decap_6
X_1834_ VGND VPWR VGND VPWR _2633_/Q _1833_/A _1834_/Y _1965_/S sky130_fd_sc_hd__o21ai_0
X_1765_ VPWR VGND VPWR VGND _1763_/Y _1999_/S _1764_/Y _2489_/D sky130_fd_sc_hd__a21oi_1
X_1903_ VPWR VGND VGND VPWR _1903_/A _1903_/Y _1909_/B sky130_fd_sc_hd__nand2_1
X_1696_ VPWR VGND VPWR VGND _1695_/Y _1672_/C _2096_/A _2481_/D sky130_fd_sc_hd__a21oi_1
X_2179_ VPWR VGND VPWR VGND _2178_/X _2283_/B _2173_/A _2179_/Y sky130_fd_sc_hd__a21oi_1
X_2248_ VGND VPWR VPWR VGND _2248_/A _2248_/X _2248_/B sky130_fd_sc_hd__xor2_1
X_2317_ VGND VPWR VPWR VGND _2317_/X _2318_/B _2318_/A sky130_fd_sc_hd__and2_0
XFILLER_0_277 VPWR VGND VPWR VGND sky130_fd_sc_hd__decap_3
X_1481_ VPWR VGND VGND VPWR _2272_/B _1486_/D _1515_/B sky130_fd_sc_hd__nand2_1
X_1550_ VPWR VGND VGND VPWR _1550_/A _2114_/B _1550_/B sky130_fd_sc_hd__nand2_1
X_2102_ VPWR VGND VPWR VGND _2415_/Q _2102_/D _2114_/C _2414_/Q _2102_/X sky130_fd_sc_hd__or4_1
XFILLER_11_3 VPWR VGND VPWR VGND sky130_fd_sc_hd__decap_3
X_2033_ VPWR VGND VPWR VGND _2032_/B _1227_/Y _2032_/Y _2598_/D sky130_fd_sc_hd__a21oi_1
XFILLER_22_137 VPWR VGND VPWR VGND sky130_fd_sc_hd__decap_3
XFILLER_22_159 VPWR VGND VPWR VGND sky130_fd_sc_hd__decap_3
X_1817_ VPWR VGND VGND VPWR _1815_/Y _1816_/Y _2503_/D pwm_out _2634_/D sky130_fd_sc_hd__o2bb2ai_1
Xhold344 _1800_/B _1799_/Y VPWR VGND VGND VPWR sky130_fd_sc_hd__dlygate4sd3_1
Xhold322 _1783_/A _2492_/Q VPWR VGND VGND VPWR sky130_fd_sc_hd__dlygate4sd3_1
X_1748_ VPWR VGND VGND VPWR _1755_/B _1749_/B _1755_/C sky130_fd_sc_hd__nand2_1
Xhold300 hold300/X _2562_/Q VPWR VGND VGND VPWR sky130_fd_sc_hd__dlygate4sd3_1
Xhold311 hold311/X _2570_/Q VPWR VGND VGND VPWR sky130_fd_sc_hd__dlygate4sd3_1
Xhold333 _2026_/A _2595_/Q VPWR VGND VGND VPWR sky130_fd_sc_hd__dlygate4sd3_1
XPHY_EDGE_ROW_15_Left_86 VPWR VGND VPWR VGND sky130_fd_sc_hd__decap_3
X_1679_ VPWR VGND VPWR VGND _1678_/Y _1672_/C _2136_/A _2474_/D sky130_fd_sc_hd__a21oi_1
Xhold355 hold355/X _2385_/Q VPWR VGND VGND VPWR sky130_fd_sc_hd__dlygate4sd3_1
Xhold366 hold366/X _2387_/Q VPWR VGND VGND VPWR sky130_fd_sc_hd__dlygate4sd3_1
Xhold377 hold377/X _1875_/Y VPWR VGND VGND VPWR sky130_fd_sc_hd__dlygate4sd3_1
XFILLER_53_284 VGND VPWR VPWR VGND sky130_fd_sc_hd__decap_4
X_2582_ VGND VPWR VPWR VGND _2607_/CLK _2582_/D fanout182/X _2582_/Q sky130_fd_sc_hd__dfrtp_1
XFILLER_8_141 VPWR VGND VPWR VGND sky130_fd_sc_hd__decap_3
X_1602_ VPWR VGND VPWR VGND _1600_/B _2631_/Q hold354/X _1603_/B sky130_fd_sc_hd__a21oi_1
X_1395_ VPWR VGND VGND VPWR _2255_/A _2230_/B _1396_/B sky130_fd_sc_hd__nor2_1
X_1533_ VPWR VGND VGND VPWR _2631_/Q _1488_/Y _1490_/X _2630_/Q _1533_/Y sky130_fd_sc_hd__o22ai_1
Xfanout109 VGND VPWR VGND VPWR _2438_/Q _1470_/B sky130_fd_sc_hd__clkdlybuf4s50_1
X_1464_ _2441_/Q _1464_/B _2614_/D _1464_/C VGND VPWR VPWR VGND sky130_fd_sc_hd__and3b_1
X_2016_ VPWR VGND VGND VPWR _2016_/A _2032_/B _2016_/Y sky130_fd_sc_hd__nor2_1
XFILLER_50_276 VGND VPWR VPWR VGND sky130_fd_sc_hd__decap_4
Xhold196 _1807_/A _2502_/Q VPWR VGND VGND VPWR sky130_fd_sc_hd__dlygate4sd3_1
XFILLER_26_240 VGND VPWR VPWR VGND sky130_fd_sc_hd__decap_4
Xclkbuf_leaf_12_clk VGND VPWR VGND VPWR clkbuf_leaf_9_clk/A _2592_/CLK sky130_fd_sc_hd__clkbuf_16
X_2634_ VGND VPWR VPWR VGND _2634_/CLK _2634_/D load_slew175/X _2634_/Q sky130_fd_sc_hd__dfrtp_1
X_1516_ VPWR VGND VGND VPWR _1516_/C _1516_/B _2624_/Q _1516_/Y sky130_fd_sc_hd__nor3_1
X_2565_ VGND VPWR VPWR VGND clkload2/A _2565_/D fanout155/X _2565_/Q sky130_fd_sc_hd__dfrtp_1
X_2496_ VGND VPWR VPWR VGND _2634_/CLK _2496_/D load_slew175/X _2496_/Q sky130_fd_sc_hd__dfrtp_1
X_1447_ VPWR VGND VGND VPWR _2274_/A _1447_/B _1447_/Y sky130_fd_sc_hd__nor2_1
X_1378_ VPWR VGND VGND VPWR _2159_/A _2273_/A _1407_/A sky130_fd_sc_hd__nor2_1
XPHY_EDGE_ROW_36_Left_107 VPWR VGND VPWR VGND sky130_fd_sc_hd__decap_3
XPHY_EDGE_ROW_45_Left_116 VPWR VGND VPWR VGND sky130_fd_sc_hd__decap_3
Xfanout80 VGND VPWR VGND VPWR _1458_/Y _1672_/B sky130_fd_sc_hd__clkdlybuf4s50_1
XPHY_EDGE_ROW_54_Left_125 VPWR VGND VPWR VGND sky130_fd_sc_hd__decap_3
Xfanout91 VGND VPWR VGND VPWR _2000_/S _2042_/B sky130_fd_sc_hd__clkdlybuf4s50_1
XFILLER_14_243 VGND VPWR VPWR VGND sky130_fd_sc_hd__decap_4
XPHY_EDGE_ROW_63_Left_134 VPWR VGND VPWR VGND sky130_fd_sc_hd__decap_3
X_1301_ VPWR VGND VGND VPWR _2242_/B _2176_/A _1393_/A sky130_fd_sc_hd__nor2_1
X_2281_ VPWR VGND _2295_/B _2263_/A _2282_/A _2264_/A _2281_/A2 _2262_/Y VPWR VGND
+ sky130_fd_sc_hd__a311oi_1
Xclkbuf_leaf_1_clk VGND VPWR VGND VPWR clkbuf_leaf_9_clk/A clkload2/A sky130_fd_sc_hd__clkbuf_16
X_2350_ VGND VPWR VPWR VGND _2350_/A _2350_/X _2350_/B sky130_fd_sc_hd__xor2_1
X_1232_ VPWR VGND VGND VPWR _2452_/Q _1232_/Y sky130_fd_sc_hd__inv_1
X_1996_ VGND VPWR VPWR VGND _2576_/D _2401_/Q _2038_/B hold288/X sky130_fd_sc_hd__mux2_1
X_2617_ VGND VPWR VPWR VGND _2633_/CLK _2617_/D fanout187/X _2617_/Q sky130_fd_sc_hd__dfrtp_1
X_2548_ VGND VPWR VPWR VGND clkload1/A _2548_/D load_slew150/X _2548_/Q sky130_fd_sc_hd__dfrtp_1
X_2479_ VGND VPWR VPWR VGND clkload3/A _2479_/D fanout159/A _2479_/Q sky130_fd_sc_hd__dfrtp_1
Xclkload0 VGND VPWR VGND VPWR clkload0/A clkload0/X sky130_fd_sc_hd__clkbuf_16
XPHY_EDGE_ROW_3_Left_74 VPWR VGND VPWR VGND sky130_fd_sc_hd__decap_3
XFILLER_61_113 VPWR VGND VPWR VGND sky130_fd_sc_hd__decap_6
X_1781_ VPWR VGND VPWR VGND _1774_/Y _1777_/A _2119_/D _1788_/C sky130_fd_sc_hd__a21oi_1
X_1850_ VGND VPWR VGND VPWR _1849_/Y _1945_/B _2516_/D _1848_/Y sky130_fd_sc_hd__o21ai_0
X_2402_ VGND VPWR VPWR VGND clkload9/A _2402_/D load_slew168/X _2402_/Q sky130_fd_sc_hd__dfrtp_1
X_2333_ VGND VPWR _2333_/B _2336_/A _2333_/A VPWR VGND sky130_fd_sc_hd__xnor2_1
X_1215_ VPWR VGND VGND VPWR _2473_/Q _1215_/Y sky130_fd_sc_hd__inv_1
X_2195_ VPWR VGND VPWR VGND _2425_/D fanout3/X _2184_/Y _2194_/Y _1389_/B _2196_/B
+ sky130_fd_sc_hd__o32a_1
X_2264_ VPWR VGND VGND VPWR _2264_/A _2265_/B _2264_/B sky130_fd_sc_hd__nand2_1
X_1979_ VPWR VGND VGND VPWR _2010_/B _1979_/A _2130_/A sky130_fd_sc_hd__nor2b_1
X_1902_ VPWR VGND VGND VPWR _2533_/Q _1902_/Y _2607_/Q _1902_/S sky130_fd_sc_hd__mux2i_1
X_1833_ VPWR VGND VGND VPWR _1833_/A _1833_/B _1833_/Y sky130_fd_sc_hd__nor2_1
X_1764_ VPWR VGND VGND VPWR _1764_/A _1999_/S _1764_/Y sky130_fd_sc_hd__nor2_1
X_2316_ VGND VPWR _2316_/B _2318_/B _2316_/A VPWR VGND sky130_fd_sc_hd__xnor2_1
X_1695_ VGND VPWR _1695_/B _1695_/Y _2259_/A VPWR VGND sky130_fd_sc_hd__xnor2_1
X_2178_ VGND VPWR VGND VPWR _2178_/X _2191_/C _2191_/B _2191_/A sky130_fd_sc_hd__xor3_1
X_2247_ VPWR VGND VGND VPWR _2248_/A _2264_/A _2248_/B sky130_fd_sc_hd__nand2_1
XFILLER_63_208 VPWR VGND VPWR VGND sky130_fd_sc_hd__decap_3
XPHY_EDGE_ROW_19_Right_19 VPWR VGND VPWR VGND sky130_fd_sc_hd__decap_3
X_1480_ VPWR VGND VGND VPWR _2257_/B _1512_/B _1515_/B sky130_fd_sc_hd__nor2_1
XPHY_EDGE_ROW_28_Right_28 VPWR VGND VPWR VGND sky130_fd_sc_hd__decap_3
XPHY_EDGE_ROW_37_Right_37 VPWR VGND VPWR VGND sky130_fd_sc_hd__decap_3
X_2101_ VPWR VGND VGND VPWR wire16/X _2114_/C _2101_/A _2101_/Y sky130_fd_sc_hd__nor3_1
X_2032_ VPWR VGND VGND VPWR _2032_/A _2032_/B _2032_/Y sky130_fd_sc_hd__nor2_1
Xhold345 _1825_/A _2506_/Q VPWR VGND VGND VPWR sky130_fd_sc_hd__dlygate4sd3_1
X_1678_ VGND VPWR _1678_/B _1678_/Y _2474_/Q VPWR VGND sky130_fd_sc_hd__xnor2_1
X_1816_ VGND VPWR VGND VPWR _2634_/Q _1254_/Y _1816_/Y _2494_/Q sky130_fd_sc_hd__o21ai_0
Xhold356 _1222_/A _2634_/Q VPWR VGND VGND VPWR sky130_fd_sc_hd__dlygate4sd3_1
Xhold323 hold323/X _2579_/Q VPWR VGND VGND VPWR sky130_fd_sc_hd__dlygate4sd3_1
XPHY_EDGE_ROW_46_Right_46 VPWR VGND VPWR VGND sky130_fd_sc_hd__decap_3
Xhold301 _2562_/D _1982_/X VPWR VGND VGND VPWR sky130_fd_sc_hd__dlygate4sd3_1
Xhold378 hold378/X _2588_/Q VPWR VGND VGND VPWR sky130_fd_sc_hd__dlygate4sd3_1
Xhold334 _2034_/A _2599_/Q VPWR VGND VGND VPWR sky130_fd_sc_hd__dlygate4sd3_1
Xhold367 hold367/X _2412_/Q VPWR VGND VGND VPWR sky130_fd_sc_hd__dlygate4sd3_1
Xhold312 _2570_/D _1990_/X VPWR VGND VGND VPWR sky130_fd_sc_hd__dlygate4sd3_1
X_1747_ VPWR VGND _1755_/C _1744_/Y _1741_/Y _1734_/Y _1746_/Y VGND VPWR sky130_fd_sc_hd__a31o_1
XPHY_EDGE_ROW_55_Right_55 VPWR VGND VPWR VGND sky130_fd_sc_hd__decap_3
XFILLER_26_79 VGND VPWR VPWR VGND sky130_fd_sc_hd__decap_4
XPHY_EDGE_ROW_64_Right_64 VPWR VGND VPWR VGND sky130_fd_sc_hd__decap_3
XFILLER_21_160 VPWR VGND VPWR VGND sky130_fd_sc_hd__decap_3
X_2581_ VGND VPWR VPWR VGND _2607_/CLK _2581_/D _2494_/SET_B _2581_/Q sky130_fd_sc_hd__dfrtp_1
X_1532_ VGND VPWR VGND VPWR _1531_/X _1526_/Y _1532_/Y _1529_/X sky130_fd_sc_hd__o21ai_0
XFILLER_8_197 VPWR VGND VPWR VGND sky130_fd_sc_hd__decap_8
X_1601_ VPWR VGND VGND VPWR _1603_/A _1601_/B _2631_/D sky130_fd_sc_hd__nor2_1
X_1394_ VGND VPWR VPWR VGND _1396_/A _1302_/Y _1393_/B _2257_/B _2230_/B _1427_/A
+ sky130_fd_sc_hd__a221oi_1
X_1463_ VPWR VGND VGND VPWR _1561_/B _1657_/C _1651_/B _1464_/C sky130_fd_sc_hd__nor3_1
X_2015_ VPWR VGND VPWR VGND _2032_/B _1236_/Y _2014_/Y _2589_/D sky130_fd_sc_hd__a21oi_1
XFILLER_12_37 VPWR VGND VPWR VGND sky130_fd_sc_hd__decap_8
Xhold197 _1948_/A _2549_/Q VPWR VGND VGND VPWR sky130_fd_sc_hd__dlygate4sd3_1
XFILLER_37_23 VPWR VGND VPWR VGND sky130_fd_sc_hd__decap_3
X_2633_ VGND VPWR VPWR VGND _2633_/CLK _2633_/D fanout187/X _2633_/Q sky130_fd_sc_hd__dfrtp_1
X_2495_ VGND VPWR VPWR VGND _2634_/CLK _2495_/D load_slew175/X _2495_/Q sky130_fd_sc_hd__dfrtp_1
X_1515_ VGND VPWR _1515_/B _1515_/Y _2230_/A VPWR VGND sky130_fd_sc_hd__xnor2_1
X_2564_ VGND VPWR VPWR VGND clkload2/A _2564_/D fanout155/X _2564_/Q sky130_fd_sc_hd__dfrtp_1
X_1446_ VPWR VGND VPWR VGND _2274_/A _1447_/B _1446_/Y _2481_/Q _1443_/X sky130_fd_sc_hd__a22oi_1
X_1377_ VPWR VGND VGND VPWR _1484_/A _1408_/B _2158_/B sky130_fd_sc_hd__nand2_1
XFILLER_58_141 VGND VPWR VPWR VGND sky130_fd_sc_hd__decap_12
Xfanout92 VGND VPWR VGND VPWR _2000_/S _1999_/S sky130_fd_sc_hd__clkdlybuf4s50_1
X_1300_ VGND VPWR _2242_/B _1305_/A _2257_/B VPWR VGND sky130_fd_sc_hd__xnor2_1
X_2280_ VGND VPWR VPWR VGND _2262_/Y _2281_/A2 _2264_/A _2282_/B _2263_/A sky130_fd_sc_hd__a31oi_1
X_1231_ VPWR VGND VGND VPWR _2453_/Q _1231_/Y sky130_fd_sc_hd__inv_1
X_2616_ VGND VPWR VPWR VGND _2616_/CLK input2/X fanout188/X _2616_/Q sky130_fd_sc_hd__dfrtp_1
X_1995_ VGND VPWR VPWR VGND _2575_/D _2400_/Q _2032_/B hold292/X sky130_fd_sc_hd__mux2_1
XFILLER_9_281 VPWR VGND VPWR VGND sky130_fd_sc_hd__decap_8
X_1429_ VGND VPWR _1429_/B _1434_/B _1429_/A VPWR VGND sky130_fd_sc_hd__xnor2_1
X_2478_ VGND VPWR VPWR VGND _2616_/CLK _2478_/D fanout185/X _2478_/Q sky130_fd_sc_hd__dfrtp_1
X_2547_ VGND VPWR VPWR VGND clkload7/A _2547_/D load_slew144/X _2547_/Q sky130_fd_sc_hd__dfrtp_1
XFILLER_55_177 VPWR VGND VPWR VGND sky130_fd_sc_hd__decap_3
XFILLER_11_225 VPWR VGND VPWR VGND sky130_fd_sc_hd__decap_3
Xclkload1 VGND VPWR clkload1/X clkload1/A VPWR VGND sky130_fd_sc_hd__clkbuf_1
XFILLER_1_3 VGND VPWR VPWR VGND sky130_fd_sc_hd__decap_12
Xload_slew13 VPWR VGND _2384_/S _1638_/S VPWR VGND sky130_fd_sc_hd__buf_4
Xload_slew68 VPWR VGND _1902_/S _1965_/S VPWR VGND sky130_fd_sc_hd__buf_4
X_1780_ VGND VPWR VPWR VGND _2465_/Q _1782_/A _2407_/Q sky130_fd_sc_hd__xor2_1
X_2401_ VGND VPWR VPWR VGND clkload1/A _2401_/D load_slew168/X _2401_/Q sky130_fd_sc_hd__dfrtp_1
XFILLER_34_3 VGND VPWR VPWR VGND sky130_fd_sc_hd__decap_12
X_2332_ VPWR VGND VGND VPWR _2332_/A _2346_/C _2333_/B sky130_fd_sc_hd__nand2_1
X_2194_ VPWR VGND VPWR VGND _2192_/X _2224_/A2 _2193_/Y _2194_/Y sky130_fd_sc_hd__a21oi_1
X_1214_ VPWR VGND VGND VPWR _2475_/Q _1680_/A sky130_fd_sc_hd__inv_1
X_2263_ VPWR VGND VGND VPWR _2263_/A _2263_/B _2265_/A sky130_fd_sc_hd__nor2_1
X_1978_ VPWR VGND VGND VPWR _1978_/A _2010_/B _1980_/A sky130_fd_sc_hd__nor2_1
XFILLER_29_57 VGND VPWR VPWR VGND sky130_fd_sc_hd__decap_4
XFILLER_51_191 VPWR VGND VPWR VGND sky130_fd_sc_hd__decap_3
X_1832_ VPWR VGND VPWR VGND _2506_/Q _2507_/Q i2s_ws _1833_/B _2508_/Q sky130_fd_sc_hd__nand4_1
X_1901_ VGND VPWR VGND VPWR _1900_/Y _1969_/B _1901_/Y _1899_/Y sky130_fd_sc_hd__o21ai_0
XFILLER_42_180 VGND VPWR VPWR VGND sky130_fd_sc_hd__decap_4
X_1763_ VGND VPWR _1763_/B _1763_/Y _1763_/A VPWR VGND sky130_fd_sc_hd__xnor2_1
X_1694_ VPWR VGND VPWR VGND _1693_/Y _1672_/C _1543_/B _2480_/D sky130_fd_sc_hd__a21oi_1
X_2246_ VGND VPWR VGND VPWR _2231_/Y _2230_/A _2248_/B _1303_/A sky130_fd_sc_hd__o21ai_0
X_2315_ VPWR VGND VPWR VGND _2359_/S _2149_/B _2314_/Y _2315_/Y sky130_fd_sc_hd__a21oi_1
X_2177_ VGND VPWR _2177_/B _2191_/C _2475_/Q VPWR VGND sky130_fd_sc_hd__xnor2_1
XFILLER_25_169 VGND VPWR VPWR VGND sky130_fd_sc_hd__decap_12
XFILLER_56_261 VGND VPWR VPWR VGND sky130_fd_sc_hd__decap_12
X_2100_ VPWR VGND _2082_/A _2414_/Q _2114_/C _2414_/D _2099_/Y VPWR VGND sky130_fd_sc_hd__o31ai_1
XFILLER_62_253 VPWR VGND VPWR VGND sky130_fd_sc_hd__decap_8
X_2031_ VPWR VGND VPWR VGND _2032_/B _1228_/Y _2030_/Y _2597_/D sky130_fd_sc_hd__a21oi_1
X_1815_ VPWR VGND VPWR VGND _2494_/Q _1254_/Y _1814_/X _1815_/Y sky130_fd_sc_hd__a21oi_1
XFILLER_30_183 VPWR VGND VPWR VGND sky130_fd_sc_hd__decap_8
XFILLER_30_150 VPWR VGND VPWR VGND sky130_fd_sc_hd__decap_8
X_1677_ VPWR VGND VPWR VGND _1676_/X _1672_/C _2136_/A _2473_/D sky130_fd_sc_hd__a21oi_1
Xhold357 _1828_/A _2508_/Q VPWR VGND VGND VPWR sky130_fd_sc_hd__dlygate4sd3_1
Xhold324 _1829_/A _2509_/Q VPWR VGND VGND VPWR sky130_fd_sc_hd__dlygate4sd3_1
Xhold302 _2008_/A _2586_/Q VPWR VGND VGND VPWR sky130_fd_sc_hd__dlygate4sd3_1
Xhold379 _1979_/A _2385_/Q VPWR VGND VGND VPWR sky130_fd_sc_hd__dlygate4sd3_1
Xhold335 _1223_/A _2421_/Q VPWR VGND VGND VPWR sky130_fd_sc_hd__dlygate4sd3_1
Xhold313 _2036_/A _2600_/Q VPWR VGND VGND VPWR sky130_fd_sc_hd__dlygate4sd3_1
Xhold368 hold368/X _2390_/Q VPWR VGND VGND VPWR sky130_fd_sc_hd__dlygate4sd3_1
Xhold346 _2373_/A _2441_/Q VPWR VGND VGND VPWR sky130_fd_sc_hd__dlygate4sd3_1
X_1746_ VPWR VGND VGND VPWR _2121_/A _1740_/A _1746_/Y _1734_/Y _1745_/Y _1741_/B
+ sky130_fd_sc_hd__o221ai_1
X_2229_ VGND VPWR VGND VPWR _2229_/B _2229_/A _2236_/A sky130_fd_sc_hd__or2_0
XFILLER_38_261 VPWR VGND VPWR VGND sky130_fd_sc_hd__decap_3
XFILLER_44_264 VPWR VGND VPWR VGND sky130_fd_sc_hd__decap_6
X_2580_ VGND VPWR VPWR VGND _2634_/CLK _2580_/D load_slew177/X _2580_/Q sky130_fd_sc_hd__dfrtp_1
X_1531_ VPWR VGND VGND VPWR _2629_/Q _1528_/X _2628_/Q _1530_/Y _1531_/X sky130_fd_sc_hd__o22a_1
X_1600_ VGND VPWR _1600_/B _1601_/B _2631_/Q VPWR VGND sky130_fd_sc_hd__xnor2_1
X_1462_ VPWR VGND VGND VPWR _1561_/B _2375_/B _1657_/D sky130_fd_sc_hd__nor2_1
X_1393_ VPWR VGND VGND VPWR _1393_/A _1393_/B _1427_/B sky130_fd_sc_hd__nor2_1
X_2014_ VPWR VGND VGND VPWR _2014_/A _2032_/B _2014_/Y sky130_fd_sc_hd__nor2_1
X_1729_ VPWR VGND VPWR VGND _2393_/Q _2451_/Q _1729_/Y _2452_/Q _2394_/Q sky130_fd_sc_hd__a22oi_1
Xhold198 _1657_/B _2469_/Q VPWR VGND VGND VPWR sky130_fd_sc_hd__dlygate4sd3_1
XFILLER_5_146 VGND VPWR VPWR VGND sky130_fd_sc_hd__decap_4
XFILLER_5_113 VGND VPWR VPWR VGND sky130_fd_sc_hd__decap_12
XFILLER_64_3 VGND VPWR VPWR VGND sky130_fd_sc_hd__decap_4
X_2632_ VGND VPWR VPWR VGND clkload5/A _2632_/D load_slew162/X _2632_/Q sky130_fd_sc_hd__dfrtp_1
X_2494_ VPWR VGND VPWR VGND _2494_/Q _2494_/SET_B _2494_/D _2607_/CLK sky130_fd_sc_hd__dfstp_2
X_1514_ VGND VPWR VGND VPWR _2623_/Q _1514_/A1 _1514_/Y _1491_/Y sky130_fd_sc_hd__o21ai_0
X_2563_ VGND VPWR VPWR VGND clkload2/A _2563_/D fanout155/X _2563_/Q sky130_fd_sc_hd__dfrtp_1
X_1445_ VGND VPWR wire32/X _1447_/B _1445_/A VPWR VGND sky130_fd_sc_hd__xnor2_1
X_1376_ VPWR VGND VGND VPWR _2159_/A _1470_/B _1412_/A sky130_fd_sc_hd__nor2_1
XFILLER_58_153 VPWR VGND VPWR VGND sky130_fd_sc_hd__decap_6
Xfanout82 VGND VPWR VGND VPWR _1458_/Y _2254_/B2 sky130_fd_sc_hd__clkdlybuf4s50_1
Xfanout71 VGND VPWR VGND VPWR _1833_/Y _1947_/S sky130_fd_sc_hd__clkdlybuf4s50_1
Xfanout93 VGND VPWR VGND VPWR _2000_/S _2050_/B sky130_fd_sc_hd__clkdlybuf4s50_1
XFILLER_1_193 VPWR VGND VPWR VGND sky130_fd_sc_hd__decap_8
X_1230_ VPWR VGND VGND VPWR _2454_/Q _1230_/Y sky130_fd_sc_hd__inv_1
XFILLER_20_204 VGND VPWR VPWR VGND sky130_fd_sc_hd__decap_12
X_1994_ VGND VPWR VPWR VGND _2574_/D _2399_/Q _2032_/B hold281/X sky130_fd_sc_hd__mux2_1
X_2615_ VGND VPWR VPWR VGND _2633_/CLK _2615_/D fanout187/X block_start sky130_fd_sc_hd__dfrtp_1
X_1428_ VGND VPWR _1428_/B _1435_/B _1428_/A VPWR VGND sky130_fd_sc_hd__xnor2_1
X_2477_ VGND VPWR VPWR VGND _2616_/CLK _2477_/D fanout183/A _2477_/Q sky130_fd_sc_hd__dfrtp_1
X_2546_ VGND VPWR VPWR VGND clkload6/A _2546_/D load_slew144/X _2546_/Q sky130_fd_sc_hd__dfrtp_1
XFILLER_70_104 VGND VPWR VPWR VGND sky130_fd_sc_hd__decap_4
XFILLER_34_25 VPWR VGND VPWR VGND sky130_fd_sc_hd__decap_3
XFILLER_18_37 VPWR VGND VPWR VGND sky130_fd_sc_hd__decap_3
X_1359_ VGND VPWR VGND VPWR _2158_/B _1484_/A _1470_/C sky130_fd_sc_hd__or2_0
Xclkload2 VGND VPWR VPWR VGND clkload2/A clkload2/Y sky130_fd_sc_hd__clkinv_2
XFILLER_59_66 VGND VPWR VPWR VGND sky130_fd_sc_hd__decap_4
X_2400_ VGND VPWR VPWR VGND clkload1/A _2400_/D load_slew152/X _2400_/Q sky130_fd_sc_hd__dfrtp_1
X_1213_ VPWR VGND VGND VPWR _2476_/Q _2201_/C sky130_fd_sc_hd__inv_1
X_2262_ VPWR VGND VGND VPWR _2263_/B _2262_/Y sky130_fd_sc_hd__inv_1
X_2331_ VGND VPWR _2331_/B _2333_/B _2331_/A VPWR VGND sky130_fd_sc_hd__xnor2_1
XFILLER_27_3 VPWR VGND VPWR VGND sky130_fd_sc_hd__decap_3
X_2193_ VGND VPWR VGND VPWR _2360_/A _2185_/B _2193_/Y _2224_/A2 sky130_fd_sc_hd__o21ai_0
X_1977_ VGND VPWR VPWR VGND i2s_bclk _2559_/D _1977_/B sky130_fd_sc_hd__xor2_1
X_2529_ VGND VPWR VPWR VGND clkload8/A _2529_/D fanout165/X _2529_/Q sky130_fd_sc_hd__dfrtp_1
X_1831_ VPWR VGND VGND VPWR _1831_/A _1831_/B _2510_/D sky130_fd_sc_hd__nor2_1
X_1900_ VPWR VGND VGND VPWR _1900_/A _1900_/Y _1969_/B sky130_fd_sc_hd__nand2_1
X_1762_ VGND VPWR _2404_/Q _1763_/B _2462_/Q VPWR VGND sky130_fd_sc_hd__xnor2_1
X_1693_ VPWR VGND VGND VPWR _1695_/B _1693_/Y _1693_/B sky130_fd_sc_hd__nand2_1
XPHY_EDGE_ROW_69_Left_140 VPWR VGND VPWR VGND sky130_fd_sc_hd__decap_3
X_2176_ VGND VPWR _2187_/B _2177_/B _2176_/A VPWR VGND sky130_fd_sc_hd__xnor2_1
XFILLER_57_218 VPWR VGND VPWR VGND sky130_fd_sc_hd__decap_6
X_2245_ VPWR VGND VGND VPWR _2245_/A _2260_/B _2248_/A sky130_fd_sc_hd__nor2_1
X_2314_ VGND VPWR VGND VPWR _1557_/A _2316_/A _2314_/Y _2359_/S sky130_fd_sc_hd__o21ai_0
XFILLER_65_273 VPWR VGND VPWR VGND sky130_fd_sc_hd__decap_6
XFILLER_65_251 VPWR VGND VPWR VGND sky130_fd_sc_hd__decap_8
XFILLER_0_225 VGND VPWR VPWR VGND sky130_fd_sc_hd__decap_12
XPHY_EDGE_ROW_1_Right_1 VPWR VGND VPWR VGND sky130_fd_sc_hd__decap_3
XFILLER_56_273 VPWR VGND VPWR VGND sky130_fd_sc_hd__decap_8
XFILLER_21_81 VGND VPWR VPWR VGND sky130_fd_sc_hd__decap_12
XFILLER_39_207 VPWR VGND VPWR VGND sky130_fd_sc_hd__decap_6
X_2030_ VPWR VGND VGND VPWR _2030_/A _2032_/B _2030_/Y sky130_fd_sc_hd__nor2_1
X_1814_ VPWR VGND VGND VPWR _1814_/X _1814_/C _1814_/A _2493_/Q sky130_fd_sc_hd__maj3_1
X_1745_ VPWR VGND VGND VPWR _2459_/Q _1745_/Y _2401_/Q sky130_fd_sc_hd__nand2_1
X_1676_ VGND VPWR VGND VPWR _1676_/B _1678_/B _1676_/X sky130_fd_sc_hd__or2_0
Xhold358 _1567_/A _2617_/Q VPWR VGND VGND VPWR sky130_fd_sc_hd__dlygate4sd3_1
Xhold347 hold347/X _2496_/Q VPWR VGND VGND VPWR sky130_fd_sc_hd__dlygate4sd3_1
Xhold325 _1764_/A _2489_/Q VPWR VGND VGND VPWR sky130_fd_sc_hd__dlygate4sd3_1
Xhold336 _1793_/A _2495_/Q VPWR VGND VGND VPWR sky130_fd_sc_hd__dlygate4sd3_1
Xhold303 hold303/X _2510_/Q VPWR VGND VGND VPWR sky130_fd_sc_hd__dlygate4sd3_1
Xhold314 _2012_/A _2588_/Q VPWR VGND VGND VPWR sky130_fd_sc_hd__dlygate4sd3_1
Xhold369 hold369/X _2395_/Q VPWR VGND VGND VPWR sky130_fd_sc_hd__dlygate4sd3_1
X_2228_ VPWR VGND VPWR VGND _2255_/B _2201_/C _2227_/Y _2228_/Y sky130_fd_sc_hd__a21oi_1
X_2159_ VPWR VGND VGND VPWR _2159_/A _2159_/Y _2307_/A sky130_fd_sc_hd__nand2_1
XFILLER_67_33 VPWR VGND VPWR VGND sky130_fd_sc_hd__decap_8
X_1392_ VPWR VGND VGND VPWR _2241_/B _2212_/B _1393_/B sky130_fd_sc_hd__nor2_1
X_1530_ VGND VPWR _1530_/B _1530_/Y _1530_/A VPWR VGND sky130_fd_sc_hd__xnor2_1
X_1461_ VPWR VGND VPWR VGND _1374_/B _1374_/A _2442_/Q _2375_/B sky130_fd_sc_hd__a21oi_1
X_2013_ VPWR VGND VPWR VGND _2038_/B _1237_/Y _2012_/Y _2588_/D sky130_fd_sc_hd__a21oi_1
XFILLER_50_246 VPWR VGND VPWR VGND sky130_fd_sc_hd__decap_6
XFILLER_35_265 VPWR VGND VPWR VGND sky130_fd_sc_hd__decap_8
XFILLER_35_254 VPWR VGND VPWR VGND sky130_fd_sc_hd__decap_6
X_1728_ VPWR VGND VGND VPWR _2450_/Q _2392_/Q _2126_/B sky130_fd_sc_hd__nor2_1
X_1659_ VGND VPWR _1678_/B _2472_/Q _2473_/Q _2471_/Q VPWR VGND sky130_fd_sc_hd__and3_1
Xhold199 _1939_/A _2546_/Q VPWR VGND VGND VPWR sky130_fd_sc_hd__dlygate4sd3_1
XFILLER_53_57 VPWR VGND VPWR VGND sky130_fd_sc_hd__decap_3
XFILLER_32_268 VGND VPWR VPWR VGND sky130_fd_sc_hd__decap_4
X_2562_ VGND VPWR VPWR VGND clkload8/A _2562_/D load_slew172/X _2562_/Q sky130_fd_sc_hd__dfrtp_1
X_2631_ VGND VPWR VPWR VGND clkload5/A _2631_/D load_slew162/X _2631_/Q sky130_fd_sc_hd__dfrtp_1
X_2493_ VGND VPWR VPWR VGND _2607_/CLK _2493_/D _2494_/SET_B _2493_/Q sky130_fd_sc_hd__dfrtp_1
Xclkbuf_leaf_4_clk VGND VPWR VGND VPWR clkload0/A _2634_/CLK sky130_fd_sc_hd__clkbuf_16
X_1513_ VGND VPWR VGND VPWR _2624_/Q _1514_/A1 _1513_/Y _1516_/C sky130_fd_sc_hd__o21ai_0
X_1375_ VPWR VGND VGND VPWR _2442_/Q _1375_/Y _2167_/A sky130_fd_sc_hd__nand2_1
X_1444_ VPWR VGND VGND VPWR _2480_/Q _1421_/X _1444_/Y _2481_/Q _1441_/Y _1443_/X
+ sky130_fd_sc_hd__o221ai_1
XFILLER_23_235 VGND VPWR VPWR VGND sky130_fd_sc_hd__decap_4
Xfanout94 VGND VPWR VGND VPWR _2000_/S _2003_/S sky130_fd_sc_hd__clkdlybuf4s50_1
Xfanout50 VGND VPWR VGND VPWR _1909_/B _1951_/B sky130_fd_sc_hd__clkdlybuf4s50_1
Xfanout61 VGND VPWR VGND VPWR _1932_/S _1926_/S sky130_fd_sc_hd__clkdlybuf4s50_1
XPHY_EDGE_ROW_32_Left_103 VPWR VGND VPWR VGND sky130_fd_sc_hd__decap_3
XPHY_EDGE_ROW_41_Left_112 VPWR VGND VPWR VGND sky130_fd_sc_hd__decap_3
XFILLER_9_261 VPWR VGND VPWR VGND sky130_fd_sc_hd__decap_3
X_1993_ VGND VPWR VPWR VGND _2573_/D _2398_/Q _2020_/B hold331/X sky130_fd_sc_hd__mux2_1
XFILLER_20_216 VGND VPWR VPWR VGND sky130_fd_sc_hd__decap_12
X_2545_ VGND VPWR VPWR VGND clkload6/A _2545_/D load_slew142/X _2545_/Q sky130_fd_sc_hd__dfrtp_1
X_2614_ VGND VPWR VPWR VGND clkload5/A _2614_/D fanout155/X _2614_/Q sky130_fd_sc_hd__dfrtp_1
X_2476_ VGND VPWR VPWR VGND _2616_/CLK _2476_/D fanout191/X _2476_/Q sky130_fd_sc_hd__dfrtp_1
XPHY_EDGE_ROW_50_Left_121 VPWR VGND VPWR VGND sky130_fd_sc_hd__decap_3
X_1427_ VGND VPWR _1427_/B _1436_/B _1427_/A VPWR VGND sky130_fd_sc_hd__xnor2_1
X_1358_ VPWR VGND VGND VPWR _1484_/A _2158_/B _1358_/Y sky130_fd_sc_hd__nor2_1
XFILLER_70_149 VPWR VGND VPWR VGND sky130_fd_sc_hd__decap_3
X_1289_ VGND VPWR _1289_/X _1289_/B _1289_/A _1289_/C VPWR VGND sky130_fd_sc_hd__and3_1
Xclkload3 VGND VPWR VGND VPWR clkload3/Y clkload3/A sky130_fd_sc_hd__inv_8
X_2192_ VGND VPWR VPWR VGND _2192_/A _2192_/X _2192_/B sky130_fd_sc_hd__xor2_1
X_1212_ VPWR VGND VGND VPWR _2477_/Q _2200_/A sky130_fd_sc_hd__inv_1
X_2261_ VPWR VGND VGND VPWR _2260_/A _2260_/B _2260_/C _2263_/B sky130_fd_sc_hd__o21a_1
X_2330_ VPWR VGND VGND VPWR _2331_/A _2346_/B _2330_/B sky130_fd_sc_hd__nand2_1
X_1976_ VGND VPWR VGND VPWR _1975_/Y _1975_/B _2558_/D _1974_/Y sky130_fd_sc_hd__o21ai_0
X_2528_ VGND VPWR VPWR VGND clkload8/A _2528_/D load_slew166/X _2528_/Q sky130_fd_sc_hd__dfrtp_1
X_2459_ VGND VPWR VPWR VGND clkload9/A _2459_/D load_slew168/X _2459_/Q sky130_fd_sc_hd__dfrtp_1
XFILLER_61_57 VGND VPWR VPWR VGND sky130_fd_sc_hd__decap_4
XPHY_EDGE_ROW_7_Left_78 VPWR VGND VPWR VGND sky130_fd_sc_hd__decap_3
XFILLER_19_113 VPWR VGND VPWR VGND sky130_fd_sc_hd__decap_6
X_1830_ VGND VPWR VPWR VGND _1828_/B _2508_/Q hold373/X _1831_/B hold303/X sky130_fd_sc_hd__a31oi_1
X_1761_ VPWR VGND VGND VPWR _2462_/Q _2404_/Q _2119_/B sky130_fd_sc_hd__nor2_1
X_2313_ VPWR VGND VPWR VGND _2433_/D fanout3/X _2302_/Y _2312_/Y _2305_/B _2327_/B
+ sky130_fd_sc_hd__o32a_1
X_1692_ VPWR VGND VGND VPWR _1692_/A _1693_/B _1692_/B sky130_fd_sc_hd__nand2_1
X_2175_ VGND VPWR VPWR VGND _2175_/X _2472_/Q _2255_/B _1431_/B sky130_fd_sc_hd__mux2_1
XFILLER_57_208 VPWR VGND VPWR VGND sky130_fd_sc_hd__decap_3
X_2244_ VGND VPWR VPWR VGND _2260_/B _2244_/B _2480_/Q sky130_fd_sc_hd__and2_0
X_1959_ VPWR VGND VGND VPWR _2552_/Q _1959_/Y _2578_/Q _1965_/S sky130_fd_sc_hd__mux2i_1
XFILLER_0_237 VGND VPWR VPWR VGND sky130_fd_sc_hd__decap_12
XFILLER_47_285 VGND VPWR VPWR VGND sky130_fd_sc_hd__decap_4
Xclkbuf_0_clk VGND VPWR VGND VPWR clk clkbuf_0_clk/X sky130_fd_sc_hd__clkbuf_16
XFILLER_15_160 VPWR VGND VPWR VGND sky130_fd_sc_hd__decap_8
X_1813_ VPWR VGND VGND VPWR _1814_/C _1813_/C _1813_/A _2492_/Q sky130_fd_sc_hd__maj3_1
Xhold326 _1771_/A _2490_/Q VPWR VGND VGND VPWR sky130_fd_sc_hd__dlygate4sd3_1
Xhold315 _2014_/A _2589_/Q VPWR VGND VGND VPWR sky130_fd_sc_hd__dlygate4sd3_1
Xhold304 _2028_/A _2596_/Q VPWR VGND VGND VPWR sky130_fd_sc_hd__dlygate4sd3_1
X_1744_ VGND VPWR VGND VPWR _1742_/Y _1730_/X _1744_/Y _1743_/X sky130_fd_sc_hd__o21ai_0
X_1675_ VPWR VGND VPWR VGND _2471_/Q _2472_/Q _2473_/Q _1676_/B sky130_fd_sc_hd__a21oi_1
Xhold348 _1796_/B _1795_/Y VPWR VGND VGND VPWR sky130_fd_sc_hd__dlygate4sd3_1
Xhold337 _2495_/D _1793_/X VPWR VGND VGND VPWR sky130_fd_sc_hd__dlygate4sd3_1
Xhold359 hold359/X _2402_/Q VPWR VGND VGND VPWR sky130_fd_sc_hd__dlygate4sd3_1
XPHY_EDGE_ROW_15_Right_15 VPWR VGND VPWR VGND sky130_fd_sc_hd__decap_3
XFILLER_53_200 VGND VPWR VPWR VGND sky130_fd_sc_hd__decap_4
X_2227_ VGND VPWR VGND VPWR _2173_/A _2201_/A _2227_/Y _2255_/B sky130_fd_sc_hd__o21ai_0
X_2089_ VPWR VGND VGND VPWR _2080_/Y _2088_/Y _2412_/D _2078_/Y hold367/X sky130_fd_sc_hd__o2bb2ai_1
X_2158_ VPWR VGND VGND VPWR _2485_/Q _2158_/B _2158_/Y sky130_fd_sc_hd__nand2b_1
XPHY_EDGE_ROW_24_Right_24 VPWR VGND VPWR VGND sky130_fd_sc_hd__decap_3
XFILLER_21_174 VPWR VGND VPWR VGND sky130_fd_sc_hd__decap_8
XPHY_EDGE_ROW_33_Right_33 VPWR VGND VPWR VGND sky130_fd_sc_hd__decap_3
XFILLER_44_211 VPWR VGND VPWR VGND sky130_fd_sc_hd__decap_3
XPHY_EDGE_ROW_42_Right_42 VPWR VGND VPWR VGND sky130_fd_sc_hd__decap_3
XPHY_EDGE_ROW_51_Right_51 VPWR VGND VPWR VGND sky130_fd_sc_hd__decap_3
XFILLER_8_189 VPWR VGND VPWR VGND sky130_fd_sc_hd__decap_6
XFILLER_12_141 VPWR VGND VPWR VGND sky130_fd_sc_hd__decap_3
X_1391_ VPWR VGND VGND VPWR _1427_/A _1428_/A _2201_/A _1391_/B sky130_fd_sc_hd__maj3_1
X_1460_ VPWR VGND VGND VPWR _2379_/A _1561_/B _1543_/B sky130_fd_sc_hd__nand2_1
XPHY_EDGE_ROW_60_Right_60 VPWR VGND VPWR VGND sky130_fd_sc_hd__decap_3
X_2012_ VPWR VGND VGND VPWR _2012_/A _2038_/B _2012_/Y sky130_fd_sc_hd__nor2_1
XFILLER_50_203 VGND VPWR VPWR VGND sky130_fd_sc_hd__decap_4
X_1727_ VPWR VGND VGND VPWR _2451_/Q _2393_/Q _2126_/A sky130_fd_sc_hd__nor2_1
X_1658_ VGND VPWR VGND VPWR _1657_/Y _1255_/Y _2470_/D _1464_/C sky130_fd_sc_hd__o21ai_0
X_1589_ VGND VPWR _1594_/C _2626_/Q _2627_/Q _1589_/C VPWR VGND sky130_fd_sc_hd__and3_1
XFILLER_41_247 VGND VPWR VPWR VGND sky130_fd_sc_hd__decap_4
XFILLER_41_225 VPWR VGND VPWR VGND sky130_fd_sc_hd__decap_8
X_2492_ VGND VPWR VPWR VGND _2607_/CLK _2492_/D _2494_/SET_B _2492_/Q sky130_fd_sc_hd__dfrtp_1
X_1512_ VGND VPWR _1512_/B _1516_/C _1512_/A VPWR VGND sky130_fd_sc_hd__xnor2_1
X_2561_ VGND VPWR VPWR VGND _2606_/CLK _2561_/D load_slew172/X _2561_/Q sky130_fd_sc_hd__dfrtp_1
X_2630_ VGND VPWR VPWR VGND clkload5/A _2630_/D load_slew162/X _2630_/Q sky130_fd_sc_hd__dfrtp_1
X_1374_ VPWR VGND VGND VPWR _1374_/A _2168_/A _1374_/B sky130_fd_sc_hd__nand2_1
X_1443_ VGND VPWR VPWR VGND _1443_/A _1443_/X _1443_/B sky130_fd_sc_hd__xor2_1
XFILLER_58_133 VGND VPWR VPWR VGND sky130_fd_sc_hd__decap_4
Xfanout51 VGND VPWR VGND VPWR _1909_/B _1954_/B sky130_fd_sc_hd__clkdlybuf4s50_1
XFILLER_14_225 VPWR VGND VPWR VGND sky130_fd_sc_hd__decap_8
Xfanout84 VGND VPWR VGND VPWR _1256_/Y _2360_/A sky130_fd_sc_hd__clkdlybuf4s50_1
Xfanout95 VGND VPWR VGND VPWR _2614_/Q _2000_/S sky130_fd_sc_hd__clkdlybuf4s50_1
Xclkload10 VGND VPWR clkload10/X _2634_/CLK VPWR VGND sky130_fd_sc_hd__clkbuf_1
X_1992_ VGND VPWR VPWR VGND _1992_/X _2397_/Q _2020_/B hold278/X sky130_fd_sc_hd__mux2_1
XFILLER_20_228 VGND VPWR VPWR VGND sky130_fd_sc_hd__decap_4
X_2613_ VGND VPWR VPWR VGND _2616_/CLK _2613_/D fanout190/X _2613_/Q sky130_fd_sc_hd__dfrtp_1
X_2475_ VGND VPWR VPWR VGND _2616_/CLK _2475_/D fanout190/X _2475_/Q sky130_fd_sc_hd__dfrtp_1
X_2544_ VGND VPWR VPWR VGND clkload6/A _2544_/D load_slew142/X _2544_/Q sky130_fd_sc_hd__dfrtp_1
X_1288_ VPWR VGND VGND VPWR _2212_/B _2137_/A _1289_/C _1269_/Y _1266_/Y _1472_/A
+ sky130_fd_sc_hd__o221ai_1
X_1426_ VGND VPWR _1426_/B _1437_/B _1426_/A VPWR VGND sky130_fd_sc_hd__xnor2_1
X_1357_ VPWR VGND VGND VPWR _1357_/A _1357_/B _1357_/Y sky130_fd_sc_hd__nor2_1
XFILLER_55_169 VPWR VGND VPWR VGND sky130_fd_sc_hd__decap_3
Xclkload4 VPWR VGND VPWR VGND clkload4/Y clkload4/A sky130_fd_sc_hd__inv_4
XFILLER_6_265 VGND VPWR VPWR VGND sky130_fd_sc_hd__decap_12
X_2191_ VPWR VGND VGND VPWR _2192_/B _2191_/C _2191_/A _2191_/B sky130_fd_sc_hd__maj3_1
X_1211_ VPWR VGND VGND VPWR _2478_/Q _1688_/A sky130_fd_sc_hd__inv_1
X_2260_ VPWR VGND VGND VPWR _2260_/C _2260_/B _2260_/A _2263_/A sky130_fd_sc_hd__nor3_1
XFILLER_37_169 VGND VPWR VPWR VGND sky130_fd_sc_hd__decap_12
XPHY_EDGE_ROW_23_Left_94 VPWR VGND VPWR VGND sky130_fd_sc_hd__decap_3
X_1975_ VPWR VGND VGND VPWR _1975_/A _1975_/Y _1975_/B sky130_fd_sc_hd__nand2_1
X_2527_ VGND VPWR VPWR VGND clkload8/A _2527_/D load_slew168/X _2527_/Q sky130_fd_sc_hd__dfrtp_1
X_2458_ VGND VPWR VPWR VGND clkload2/A _2458_/D fanout151/X _2458_/Q sky130_fd_sc_hd__dfrtp_1
X_1409_ _1415_/A _1358_/Y _1407_/A _1407_/B _1408_/B VPWR VGND VGND VPWR sky130_fd_sc_hd__o31a_1
X_2389_ VGND VPWR VPWR VGND clkload2/A _2389_/D fanout153/X _2389_/Q sky130_fd_sc_hd__dfrtp_1
X_1760_ VPWR VGND VGND VPWR _2462_/Q _1760_/Y _2404_/Q sky130_fd_sc_hd__nand2_1
X_1691_ VPWR VGND VPWR VGND _1690_/Y _1672_/C _1543_/B _2479_/D sky130_fd_sc_hd__a21oi_1
X_2312_ VPWR VGND VPWR VGND _2312_/Y _1557_/A _2303_/Y _2351_/B _2311_/Y sky130_fd_sc_hd__a211oi_1
X_2174_ VPWR VGND VPWR VGND _2423_/D fanout3/X _2166_/Y _2173_/Y _2171_/A _2196_/B
+ sky130_fd_sc_hd__o32a_1
X_2243_ VPWR VGND VGND VPWR _2480_/Q _2244_/B _2245_/A sky130_fd_sc_hd__nor2_1
X_1958_ VGND VPWR VGND VPWR _1957_/Y _1966_/B _1958_/Y _1956_/Y sky130_fd_sc_hd__o21ai_0
X_1889_ VGND VPWR VGND VPWR _1888_/Y _1954_/B _1889_/Y _1887_/Y sky130_fd_sc_hd__o21ai_0
XFILLER_0_249 VPWR VGND VPWR VGND sky130_fd_sc_hd__decap_3
XFILLER_24_183 VGND VPWR VPWR VGND sky130_fd_sc_hd__decap_12
XFILLER_47_231 VPWR VGND VPWR VGND sky130_fd_sc_hd__decap_8
XFILLER_62_245 VPWR VGND VPWR VGND sky130_fd_sc_hd__decap_6
XFILLER_15_183 VGND VPWR VPWR VGND sky130_fd_sc_hd__decap_12
X_1674_ VPWR VGND VPWR VGND _1673_/Y _1672_/C _2136_/A _2472_/D sky130_fd_sc_hd__a21oi_1
Xhold349 _1259_/A _2494_/Q VPWR VGND VGND VPWR sky130_fd_sc_hd__dlygate4sd3_1
Xhold327 _1778_/A _2491_/Q VPWR VGND VGND VPWR sky130_fd_sc_hd__dlygate4sd3_1
X_1812_ VPWR VGND VGND VPWR _1813_/C _1812_/C _1812_/A _2491_/Q sky130_fd_sc_hd__maj3_1
Xhold316 _2048_/A _2606_/Q VPWR VGND VGND VPWR sky130_fd_sc_hd__dlygate4sd3_1
XFILLER_30_197 VPWR VGND VPWR VGND sky130_fd_sc_hd__decap_6
XFILLER_30_175 VPWR VGND VPWR VGND sky130_fd_sc_hd__decap_3
Xhold338 _1870_/A _2523_/Q VPWR VGND VGND VPWR sky130_fd_sc_hd__dlygate4sd3_1
X_1743_ VPWR VGND VPWR VGND _2126_/C _2125_/B _2126_/D _1743_/A _1743_/X sky130_fd_sc_hd__or4_1
Xhold305 _2032_/A _2598_/Q VPWR VGND VGND VPWR sky130_fd_sc_hd__dlygate4sd3_1
X_2226_ VPWR VGND VGND VPWR _2427_/D _2225_/Y fanout3/X _2254_/B2 _2212_/B sky130_fd_sc_hd__a2bb2oi_1
XFILLER_38_253 VPWR VGND VPWR VGND sky130_fd_sc_hd__decap_8
X_2088_ VPWR VGND VGND VPWR _2088_/A _2088_/Y _2090_/B sky130_fd_sc_hd__nand2_1
XFILLER_13_109 VPWR VGND VPWR VGND sky130_fd_sc_hd__decap_3
X_2157_ VPWR VGND VGND VPWR _2159_/A _2307_/A _2289_/A _2331_/A _2157_/Y sky130_fd_sc_hd__o22ai_1
XFILLER_26_39 VGND VPWR VPWR VGND sky130_fd_sc_hd__decap_12
XPHY_EDGE_ROW_10_Left_81 VPWR VGND VPWR VGND sky130_fd_sc_hd__decap_3
XFILLER_44_245 VPWR VGND VPWR VGND sky130_fd_sc_hd__decap_6
XFILLER_12_197 VGND VPWR VPWR VGND sky130_fd_sc_hd__decap_4
X_1390_ VGND VPWR VPWR VGND _2201_/A _1428_/B _1391_/B sky130_fd_sc_hd__xor2_1
X_2011_ VPWR VGND VPWR VGND _2010_/B _1238_/Y _2010_/Y _2587_/D sky130_fd_sc_hd__a21oi_1
X_1588_ VPWR VGND VGND VPWR _1603_/A _1588_/B _2626_/D sky130_fd_sc_hd__nor2_1
X_1657_ VPWR VGND VPWR VGND _2468_/Q _1657_/C _1657_/D _1657_/Y _1657_/B sky130_fd_sc_hd__nand4_1
X_1726_ VPWR VGND VPWR VGND _2124_/C _1723_/X _1725_/X _1726_/Y sky130_fd_sc_hd__a21oi_1
X_2209_ VPWR VGND VPWR VGND _2197_/X _2365_/B1 _2254_/B2 _2209_/Y sky130_fd_sc_hd__a21oi_1
XFILLER_5_105 VPWR VGND VPWR VGND sky130_fd_sc_hd__decap_6
X_2491_ VGND VPWR VPWR VGND _2634_/CLK _2491_/D fanout174/X _2491_/Q sky130_fd_sc_hd__dfrtp_1
X_1511_ VPWR VGND _2623_/Q _1514_/A1 _1491_/Y _1511_/Y _1510_/Y VPWR VGND sky130_fd_sc_hd__o31ai_1
X_2560_ VGND VPWR VPWR VGND _2606_/CLK _2560_/D load_slew172/X _2560_/Q sky130_fd_sc_hd__dfrtp_1
X_1442_ VPWR VGND VGND VPWR _1443_/B _1442_/C _1486_/A _2283_/A sky130_fd_sc_hd__maj3_1
X_1373_ VPWR VGND VPWR VGND _1371_/Y _2331_/B _1369_/Y _1373_/X sky130_fd_sc_hd__a21o_1
XFILLER_31_281 VPWR VGND VPWR VGND sky130_fd_sc_hd__decap_8
X_1709_ VGND VPWR VGND VPWR _2402_/Q _2460_/Q _2123_/B sky130_fd_sc_hd__or2_0
Xfanout52 VGND VPWR VGND VPWR _1975_/B _1909_/B sky130_fd_sc_hd__clkdlybuf4s50_1
Xfanout63 VGND VPWR VGND VPWR _1947_/S _1917_/S sky130_fd_sc_hd__clkdlybuf4s50_1
Xfanout85 VGND VPWR VGND VPWR _2020_/B _2028_/B sky130_fd_sc_hd__clkdlybuf4s50_1
Xfanout96 VGND VPWR VGND VPWR _2379_/A _2082_/A sky130_fd_sc_hd__clkdlybuf4s50_1
Xfanout30 VGND VPWR VGND VPWR _1671_/Y _1672_/C sky130_fd_sc_hd__clkdlybuf4s50_1
XFILLER_49_189 VGND VPWR VPWR VGND sky130_fd_sc_hd__decap_12
XFILLER_1_163 VGND VPWR VPWR VGND sky130_fd_sc_hd__decap_4
X_2612_ VGND VPWR VPWR VGND _2633_/CLK _2612_/D fanout190/X _2612_/Q sky130_fd_sc_hd__dfrtp_1
Xclkload11 VGND VPWR clkload11/X _2607_/CLK VPWR VGND sky130_fd_sc_hd__clkbuf_1
XFILLER_62_3 VGND VPWR VPWR VGND sky130_fd_sc_hd__decap_4
XFILLER_13_281 VPWR VGND VPWR VGND sky130_fd_sc_hd__decap_8
X_1991_ VGND VPWR VPWR VGND _2571_/D _2396_/Q _2020_/B hold329/X sky130_fd_sc_hd__mux2_1
X_2474_ VGND VPWR VPWR VGND _2616_/CLK _2474_/D fanout190/X _2474_/Q sky130_fd_sc_hd__dfrtp_1
X_1425_ VPWR VGND VPWR VGND _1427_/A _1302_/Y _1393_/B _1426_/B sky130_fd_sc_hd__a21oi_1
X_2543_ VGND VPWR VPWR VGND _2592_/CLK _2543_/D load_slew147/X _2543_/Q sky130_fd_sc_hd__dfrtp_1
X_1287_ VPWR VGND VGND VPWR _1287_/A _1287_/B _1289_/B sky130_fd_sc_hd__nor2_1
X_1356_ VGND VPWR VGND VPWR _1356_/B _2484_/Q _1356_/X sky130_fd_sc_hd__or2_0
Xclkload5 VGND VPWR VGND VPWR clkload5/A clkload5/Y sky130_fd_sc_hd__bufinv_16
XFILLER_6_277 VGND VPWR VPWR VGND sky130_fd_sc_hd__decap_12
X_2190_ VPWR VGND VGND VPWR _2189_/Y _2190_/A _2192_/A sky130_fd_sc_hd__nor2b_1
X_1210_ VPWR VGND VGND VPWR _1690_/A _2232_/A sky130_fd_sc_hd__inv_1
X_1974_ VPWR VGND VGND VPWR _2557_/Q _1974_/Y _2583_/Q _1974_/S sky130_fd_sc_hd__mux2i_1
X_2388_ VGND VPWR VPWR VGND clkload8/A _2388_/D load_slew172/X _2388_/Q sky130_fd_sc_hd__dfrtp_1
X_2526_ VGND VPWR VPWR VGND clkload2/A _2526_/D load_slew152/X _2526_/Q sky130_fd_sc_hd__dfrtp_1
X_1408_ VGND VPWR VPWR VGND _1416_/B _1408_/B _1470_/C sky130_fd_sc_hd__and2_0
X_2457_ VGND VPWR VPWR VGND clkload1/A _2457_/D load_slew150/X _2457_/Q sky130_fd_sc_hd__dfrtp_1
X_1339_ VGND VPWR _1341_/B _1339_/B _1339_/A _1339_/C VPWR VGND sky130_fd_sc_hd__and3_1
XFILLER_28_137 VPWR VGND VPWR VGND sky130_fd_sc_hd__decap_3
XFILLER_3_225 VGND VPWR VPWR VGND sky130_fd_sc_hd__decap_4
XFILLER_59_240 VPWR VGND VPWR VGND sky130_fd_sc_hd__decap_3
XFILLER_19_137 VGND VPWR VPWR VGND sky130_fd_sc_hd__decap_12
XFILLER_27_192 VPWR VGND VPWR VGND sky130_fd_sc_hd__decap_6
X_1690_ VGND VPWR _1690_/B _1690_/Y _1690_/A VPWR VGND sky130_fd_sc_hd__xnor2_1
X_2242_ VGND VPWR _2242_/B _2244_/B _2242_/A VPWR VGND sky130_fd_sc_hd__xnor2_1
X_2311_ VGND VPWR _2322_/C _2311_/Y _2311_/A VPWR VGND sky130_fd_sc_hd__xnor2_1
XPHY_EDGE_ROW_29_Left_100 VPWR VGND VPWR VGND sky130_fd_sc_hd__decap_3
X_2173_ VPWR VGND VGND VPWR _2173_/C _2173_/B _2173_/A _2173_/Y sky130_fd_sc_hd__nor3_1
XFILLER_25_129 VPWR VGND VPWR VGND sky130_fd_sc_hd__decap_3
X_1957_ VPWR VGND VGND VPWR _1957_/A _1957_/Y _1966_/B sky130_fd_sc_hd__nand2_1
X_2509_ VGND VPWR VPWR VGND _2633_/CLK _2509_/D fanout187/A _2509_/Q sky130_fd_sc_hd__dfrtp_1
X_1888_ VPWR VGND VGND VPWR _1888_/A _1888_/Y _1954_/B sky130_fd_sc_hd__nand2_1
XFILLER_16_107 VGND VPWR VPWR VGND sky130_fd_sc_hd__decap_4
X_1811_ VPWR VGND VGND VPWR _1812_/C _1811_/C _1811_/A _2490_/Q sky130_fd_sc_hd__maj3_1
XFILLER_15_173 VPWR VGND VPWR VGND sky130_fd_sc_hd__decap_6
X_1673_ VGND VPWR _2471_/Q _1673_/Y _2472_/Q VPWR VGND sky130_fd_sc_hd__xnor2_1
Xhold328 _2050_/A _2607_/Q VPWR VGND VGND VPWR sky130_fd_sc_hd__dlygate4sd3_1
Xhold306 _2044_/A _2604_/Q VPWR VGND VGND VPWR sky130_fd_sc_hd__dlygate4sd3_1
Xhold317 _2006_/A _2585_/Q VPWR VGND VGND VPWR sky130_fd_sc_hd__dlygate4sd3_1
Xhold339 hold339/X _2431_/Q VPWR VGND VGND VPWR sky130_fd_sc_hd__dlygate4sd3_1
X_1742_ VGND VPWR VGND VPWR _1743_/A _2454_/Q _1742_/Y _2396_/Q sky130_fd_sc_hd__o21ai_0
X_2225_ VPWR VGND VGND VPWR _2360_/A _2211_/Y _2223_/X _2224_/Y _2225_/Y sky130_fd_sc_hd__o22ai_1
XPHY_EDGE_ROW_5_Right_5 VPWR VGND VPWR VGND sky130_fd_sc_hd__decap_3
X_2087_ VPWR VGND VPWR VGND _2410_/Q _2412_/Q _2411_/Q _2090_/B _2409_/Q sky130_fd_sc_hd__nand4_1
X_2156_ VPWR VGND VGND VPWR _2330_/B _2486_/Q _2156_/Y sky130_fd_sc_hd__nor2_1
XFILLER_21_121 VGND VPWR VPWR VGND sky130_fd_sc_hd__decap_4
XFILLER_67_14 VGND VPWR VPWR VGND sky130_fd_sc_hd__decap_4
XFILLER_44_235 VGND VPWR VPWR VGND sky130_fd_sc_hd__decap_4
XFILLER_29_221 VPWR VGND VPWR VGND sky130_fd_sc_hd__decap_3
XFILLER_12_165 VGND VPWR VPWR VGND sky130_fd_sc_hd__decap_12
XFILLER_8_147 VPWR VGND VPWR VGND sky130_fd_sc_hd__decap_8
XFILLER_8_169 VPWR VGND VPWR VGND sky130_fd_sc_hd__decap_8
X_2010_ VPWR VGND VGND VPWR _2010_/A _2010_/B _2010_/Y sky130_fd_sc_hd__nor2_1
XFILLER_57_91 VGND VPWR VPWR VGND sky130_fd_sc_hd__decap_4
XFILLER_35_202 VPWR VGND VPWR VGND sky130_fd_sc_hd__decap_6
X_1725_ VPWR VGND VPWR VGND _2449_/Q _2450_/Q _2392_/Q _1725_/X _2391_/Q sky130_fd_sc_hd__a22o_1
Xclkbuf_leaf_7_clk VGND VPWR VGND VPWR clkload0/A _2633_/CLK sky130_fd_sc_hd__clkbuf_16
X_1587_ VGND VPWR _1589_/C _1588_/B _2626_/Q VPWR VGND sky130_fd_sc_hd__xnor2_1
X_1656_ VGND VPWR VPWR VGND _1655_/X _1657_/D _1657_/B _2469_/D _1654_/Y sky130_fd_sc_hd__a31oi_1
X_2139_ VPWR VGND VGND VPWR _2140_/C _2472_/Q _1200_/Y _2423_/Q _2138_/Y sky130_fd_sc_hd__a2bb2oi_1
X_2208_ VGND VPWR VGND VPWR _2207_/Y _2198_/B _2208_/Y _2224_/A2 sky130_fd_sc_hd__o21ai_0
XFILLER_53_38 VGND VPWR VPWR VGND sky130_fd_sc_hd__decap_12
X_2490_ VGND VPWR VPWR VGND _2634_/CLK _2490_/D load_slew175/X _2490_/Q sky130_fd_sc_hd__dfrtp_1
X_1510_ VGND VPWR VGND VPWR _1509_/Y _1505_/Y _1510_/Y _1508_/Y sky130_fd_sc_hd__o21ai_0
X_1441_ VPWR VGND VGND VPWR _1692_/A _1420_/Y _1441_/Y _1439_/Y _1440_/Y _1438_/Y
+ sky130_fd_sc_hd__o221ai_1
XFILLER_4_150 VPWR VGND VPWR VGND sky130_fd_sc_hd__decap_8
X_1372_ VPWR VGND VPWR VGND _1371_/Y _2331_/B _1369_/Y _1374_/B sky130_fd_sc_hd__a21oi_1
X_1708_ VPWR VGND VGND VPWR _1708_/A _2038_/B _1708_/Y sky130_fd_sc_hd__nor2_1
X_1639_ VPWR VGND VGND VPWR _2383_/A _1639_/Y _2464_/Q sky130_fd_sc_hd__nand2_1
Xfanout53 VGND VPWR VGND VPWR _1966_/B _1969_/B sky130_fd_sc_hd__clkdlybuf4s50_1
Xfanout97 VGND VPWR VGND VPWR _2379_/A _1627_/A sky130_fd_sc_hd__clkdlybuf4s50_1
Xfanout75 VGND VPWR VGND VPWR _1543_/B _2096_/A sky130_fd_sc_hd__clkdlybuf4s50_1
Xfanout86 VGND VPWR VGND VPWR _2614_/Q _2020_/B sky130_fd_sc_hd__clkdlybuf4s50_1
X_1990_ VGND VPWR VPWR VGND _1990_/X _2395_/Q _2028_/B hold311/X sky130_fd_sc_hd__mux2_1
XFILLER_55_3 VPWR VGND VPWR VGND sky130_fd_sc_hd__decap_6
Xclkload12 clkload12/X _2606_/CLK VPWR VGND VGND VPWR sky130_fd_sc_hd__clkbuf_8
X_2542_ VGND VPWR VPWR VGND _2592_/CLK _2542_/D fanout148/X _2542_/Q sky130_fd_sc_hd__dfrtp_1
X_2611_ VGND VPWR VPWR VGND clkload4/A _2611_/D fanout157/A _2611_/Q sky130_fd_sc_hd__dfrtp_1
X_2473_ VGND VPWR VPWR VGND _2616_/CLK _2473_/D fanout190/X _2473_/Q sky130_fd_sc_hd__dfrtp_1
X_1424_ VGND VPWR _2230_/B _1426_/A _2257_/B VPWR VGND sky130_fd_sc_hd__xnor2_1
X_1355_ VGND VPWR _1355_/B _1356_/B _2356_/A VPWR VGND sky130_fd_sc_hd__xnor2_1
X_1286_ VGND VPWR VPWR VGND _1287_/B _2176_/A _2201_/A sky130_fd_sc_hd__and2_0
XFILLER_50_39 VPWR VGND VPWR VGND sky130_fd_sc_hd__decap_8
Xclkload6 VGND VPWR clkload6/X clkload6/A VPWR VGND sky130_fd_sc_hd__clkbuf_1
XFILLER_11_219 VGND VPWR VPWR VGND sky130_fd_sc_hd__decap_4
XFILLER_46_105 VPWR VGND VPWR VGND sky130_fd_sc_hd__decap_3
XFILLER_40_72 VPWR VGND VPWR VGND sky130_fd_sc_hd__decap_3
X_1973_ VGND VPWR VGND VPWR _1972_/Y _1975_/B _1973_/Y _1971_/Y sky130_fd_sc_hd__o21ai_0
X_2525_ VGND VPWR VPWR VGND clkload1/A _2525_/D load_slew152/X _2525_/Q sky130_fd_sc_hd__dfrtp_1
XFILLER_68_285 VGND VPWR VPWR VGND sky130_fd_sc_hd__decap_4
X_2387_ VGND VPWR VPWR VGND clkload8/A _2387_/D load_slew172/X _2387_/Q sky130_fd_sc_hd__dfrtp_1
X_1338_ VPWR VGND VPWR VGND _2274_/A _1337_/Y _1338_/Y _2481_/Q _1332_/B sky130_fd_sc_hd__a22oi_1
X_2456_ VGND VPWR VPWR VGND clkload1/A _2456_/D load_slew150/X _2456_/Q sky130_fd_sc_hd__dfrtp_1
X_1407_ VPWR VGND VGND VPWR _1407_/A _1407_/B _1416_/A sky130_fd_sc_hd__nor2_1
X_1269_ VGND VPWR VGND VPWR _2187_/B _2185_/B _1269_/Y _2171_/A sky130_fd_sc_hd__o21ai_0
XFILLER_51_141 VGND VPWR VPWR VGND sky130_fd_sc_hd__decap_4
XFILLER_43_108 VGND VPWR VPWR VGND sky130_fd_sc_hd__decap_4
XFILLER_19_105 VPWR VGND VPWR VGND sky130_fd_sc_hd__decap_6
XFILLER_19_149 VPWR VGND VPWR VGND sky130_fd_sc_hd__decap_8
X_2172_ VPWR VGND VGND VPWR _2297_/A _2191_/B _2173_/C sky130_fd_sc_hd__nor2_1
X_2241_ VPWR VGND VGND VPWR _2242_/A _2241_/B _2260_/A sky130_fd_sc_hd__nor2_1
X_2310_ _2322_/C _2295_/A _2295_/B _2294_/B _2291_/Y VPWR VGND VGND VPWR sky130_fd_sc_hd__o31a_1
X_1887_ VPWR VGND VGND VPWR _2528_/Q _1887_/Y _2602_/Q _1956_/S sky130_fd_sc_hd__mux2i_1
X_1956_ VPWR VGND VGND VPWR _2551_/Q _1956_/Y _2577_/Q _1956_/S sky130_fd_sc_hd__mux2i_1
XFILLER_33_185 VGND VPWR VPWR VGND sky130_fd_sc_hd__decap_12
X_2508_ VGND VPWR VPWR VGND _2633_/CLK _2508_/D fanout187/X _2508_/Q sky130_fd_sc_hd__dfrtp_1
XFILLER_0_218 VPWR VGND VPWR VGND sky130_fd_sc_hd__decap_6
X_2439_ VGND VPWR VPWR VGND clkload5/A _2439_/D load_slew162/X _2439_/Q sky130_fd_sc_hd__dfrtp_1
Xmax_cap83 VGND VPWR VPWR VGND _1269_/Y _1275_/B sky130_fd_sc_hd__clkdlybuf4s25_1
X_1810_ VPWR VGND VGND VPWR _1811_/C _1810_/C _1810_/A _2489_/Q sky130_fd_sc_hd__maj3_1
X_1741_ VPWR VGND VGND VPWR _2121_/B _1741_/B _1741_/Y sky130_fd_sc_hd__nor2_1
X_1672_ VPWR VGND VGND VPWR _2471_/Q _1672_/B _2471_/D _1672_/C sky130_fd_sc_hd__nand3_1
Xhold318 hold318/X _2488_/Q VPWR VGND VGND VPWR sky130_fd_sc_hd__dlygate4sd3_1
Xhold329 hold329/X _2571_/Q VPWR VGND VGND VPWR sky130_fd_sc_hd__dlygate4sd3_1
Xhold307 _2030_/A _2597_/Q VPWR VGND VGND VPWR sky130_fd_sc_hd__dlygate4sd3_1
X_2224_ VGND VPWR VGND VPWR _2360_/A _2176_/A _2224_/Y _2224_/A2 sky130_fd_sc_hd__o21ai_0
XFILLER_38_211 VPWR VGND VPWR VGND sky130_fd_sc_hd__decap_8
X_2155_ VPWR VGND VGND VPWR _2155_/A _2155_/Y sky130_fd_sc_hd__inv_1
X_2086_ VPWR VGND VPWR VGND _1262_/C _2412_/Q _2088_/A _2082_/B sky130_fd_sc_hd__o21bai_1
X_1939_ VPWR VGND VGND VPWR _1939_/A _1939_/Y _1942_/B sky130_fd_sc_hd__nand2_1
XPHY_EDGE_ROW_48_Left_119 VPWR VGND VPWR VGND sky130_fd_sc_hd__decap_3
XPHY_EDGE_ROW_57_Left_128 VPWR VGND VPWR VGND sky130_fd_sc_hd__decap_3
XFILLER_8_137 VPWR VGND VPWR VGND sky130_fd_sc_hd__decap_3
XPHY_EDGE_ROW_11_Right_11 VPWR VGND VPWR VGND sky130_fd_sc_hd__decap_3
XFILLER_12_177 VGND VPWR VPWR VGND sky130_fd_sc_hd__decap_12
XPHY_EDGE_ROW_20_Right_20 VPWR VGND VPWR VGND sky130_fd_sc_hd__decap_3
XPHY_EDGE_ROW_66_Left_137 VPWR VGND VPWR VGND sky130_fd_sc_hd__decap_3
X_1724_ VGND VPWR VGND VPWR _2391_/Q _2449_/Q _2124_/C sky130_fd_sc_hd__or2_0
X_1586_ VPWR VGND VGND VPWR _1586_/C _1589_/C _1603_/A _2625_/D sky130_fd_sc_hd__nor3_1
X_1655_ VGND VPWR VPWR VGND _1655_/X _1648_/Y _1657_/C _2077_/B sky130_fd_sc_hd__mux2_1
X_2138_ VPWR VGND VPWR VGND _2472_/Q _1200_/Y _2471_/Q _2138_/Y sky130_fd_sc_hd__a21oi_1
X_2207_ VPWR VGND VPWR VGND _2206_/Y _2224_/A2 _2365_/B1 _2207_/Y sky130_fd_sc_hd__a21oi_1
X_2069_ VGND VPWR VPWR VGND _2069_/X hold363/X _2074_/S _2459_/Q sky130_fd_sc_hd__mux2_1
XFILLER_17_225 VPWR VGND VPWR VGND sky130_fd_sc_hd__decap_3
X_1440_ VPWR VGND VGND VPWR _1690_/A _1440_/Y _1440_/B sky130_fd_sc_hd__nand2_1
X_1371_ VPWR VGND VGND VPWR _1371_/A _1371_/Y _1371_/B sky130_fd_sc_hd__nand2_1
XFILLER_16_280 VPWR VGND VPWR VGND sky130_fd_sc_hd__decap_8
X_1638_ VPWR VGND VGND VPWR _1243_/Y _2462_/D _1637_/Y _1638_/S sky130_fd_sc_hd__mux2i_1
X_1707_ VPWR VGND VGND VPWR _2096_/A _1707_/B _2486_/D sky130_fd_sc_hd__nor2_1
X_1569_ VPWR VGND VGND VPWR _1977_/B _1569_/B _2618_/D sky130_fd_sc_hd__nor2_1
Xfanout21 VGND VPWR VGND VPWR _2167_/X _2351_/B sky130_fd_sc_hd__clkdlybuf4s50_1
Xfanout10 VGND VPWR VGND VPWR _2380_/S _1624_/S sky130_fd_sc_hd__clkdlybuf4s50_1
XFILLER_14_217 VGND VPWR VPWR VGND sky130_fd_sc_hd__decap_4
Xfanout54 VGND VPWR VGND VPWR _1975_/B _1966_/B sky130_fd_sc_hd__clkdlybuf4s50_1
Xfanout65 VGND VPWR VGND VPWR _1971_/S _1956_/S sky130_fd_sc_hd__clkdlybuf4s50_1
Xfanout98 VGND VPWR VGND VPWR _2379_/A _2383_/A sky130_fd_sc_hd__clkdlybuf4s50_1
Xfanout76 VGND VPWR VGND VPWR _1543_/B _2327_/B sky130_fd_sc_hd__clkdlybuf4s50_1
Xfanout87 VGND VPWR VGND VPWR _2034_/B _2032_/B sky130_fd_sc_hd__clkdlybuf4s50_1
X_2472_ VGND VPWR VPWR VGND _2616_/CLK _2472_/D fanout190/X _2472_/Q sky130_fd_sc_hd__dfrtp_1
Xclkload13 VPWR VGND VPWR VGND clkload13/Y _2616_/CLK sky130_fd_sc_hd__inv_6
X_2610_ VGND VPWR VPWR VGND clkload5/A _2610_/D fanout157/A _2610_/Q sky130_fd_sc_hd__dfrtp_1
X_2541_ VGND VPWR VPWR VGND _2592_/CLK _2541_/D fanout148/X _2541_/Q sky130_fd_sc_hd__dfrtp_1
X_1285_ VPWR VGND VGND VPWR _2201_/A _2176_/A _1287_/A sky130_fd_sc_hd__nor2_1
XFILLER_48_3 VPWR VGND VPWR VGND sky130_fd_sc_hd__decap_6
X_1423_ VGND VPWR _1423_/B _1423_/Y _1423_/A VPWR VGND sky130_fd_sc_hd__xnor2_1
X_1354_ VPWR VGND VGND VPWR _1343_/X _1357_/A _1355_/B sky130_fd_sc_hd__nand2b_1
XFILLER_63_183 VGND VPWR VPWR VGND sky130_fd_sc_hd__decap_4
Xclkload7 VPWR VGND VGND VPWR clkload7/Y clkload7/A sky130_fd_sc_hd__inv_16
XFILLER_39_180 VPWR VGND VPWR VGND sky130_fd_sc_hd__decap_3
XFILLER_54_183 VGND VPWR VPWR VGND sky130_fd_sc_hd__decap_12
XFILLER_24_41 VGND VPWR VPWR VGND sky130_fd_sc_hd__decap_12
XFILLER_10_253 VPWR VGND VPWR VGND sky130_fd_sc_hd__decap_3
XFILLER_69_209 VPWR VGND VPWR VGND sky130_fd_sc_hd__decap_3
X_1972_ VPWR VGND VGND VPWR _1972_/A _1972_/Y _1975_/B sky130_fd_sc_hd__nand2_1
XFILLER_60_197 VGND VPWR VPWR VGND sky130_fd_sc_hd__decap_4
XPHY_EDGE_ROW_49_Right_49 VPWR VGND VPWR VGND sky130_fd_sc_hd__decap_3
X_2455_ VGND VPWR VPWR VGND clkload6/A _2455_/D fanout141/X _2455_/Q sky130_fd_sc_hd__dfrtp_1
X_2524_ VGND VPWR VPWR VGND clkload1/A _2524_/D load_slew152/X _2524_/Q sky130_fd_sc_hd__dfrtp_1
XFILLER_68_253 VPWR VGND VPWR VGND sky130_fd_sc_hd__decap_3
X_1268_ VGND VPWR _2185_/B _1275_/A _2198_/B VPWR VGND sky130_fd_sc_hd__xnor2_1
XPHY_EDGE_ROW_58_Right_58 VPWR VGND VPWR VGND sky130_fd_sc_hd__decap_3
X_2386_ VGND VPWR VPWR VGND clkload8/A _2386_/D load_slew172/X _2386_/Q sky130_fd_sc_hd__dfrtp_1
X_1337_ VGND VPWR _1337_/B _1337_/Y _1339_/C VPWR VGND sky130_fd_sc_hd__xnor2_1
X_1406_ VPWR VGND VGND VPWR _1407_/A _1406_/B _1418_/A sky130_fd_sc_hd__nand2b_1
X_1199_ VPWR VGND VGND VPWR _2185_/B _2201_/B sky130_fd_sc_hd__inv_1
XFILLER_51_153 VGND VPWR VPWR VGND sky130_fd_sc_hd__decap_12
XPHY_EDGE_ROW_67_Right_67 VPWR VGND VPWR VGND sky130_fd_sc_hd__decap_3
X_2171_ VPWR VGND VGND VPWR _2171_/A _2191_/B _2171_/B sky130_fd_sc_hd__nand2_1
X_2240_ VPWR VGND VGND VPWR _2198_/A _2240_/Y _2477_/Q _2255_/B sky130_fd_sc_hd__mux2i_1
XPHY_EDGE_ROW_27_Left_98 VPWR VGND VPWR VGND sky130_fd_sc_hd__decap_3
XFILLER_18_172 VGND VPWR VPWR VGND sky130_fd_sc_hd__decap_12
X_1886_ VGND VPWR VGND VPWR _1885_/Y _1954_/B _1886_/Y _1884_/Y sky130_fd_sc_hd__o21ai_0
X_1955_ VGND VPWR VGND VPWR _1954_/Y _1954_/B _2551_/D _1953_/Y sky130_fd_sc_hd__o21ai_0
X_2507_ VGND VPWR VPWR VGND _2607_/CLK _2507_/D fanout187/X _2507_/Q sky130_fd_sc_hd__dfrtp_1
X_2438_ VPWR VGND VPWR VGND _2438_/Q fanout157/X _2438_/D clkload4/A sky130_fd_sc_hd__dfstp_2
XFILLER_56_245 VPWR VGND VPWR VGND sky130_fd_sc_hd__decap_6
XFILLER_56_234 VPWR VGND VPWR VGND sky130_fd_sc_hd__decap_6
X_2369_ VGND VPWR VGND VPWR _2368_/Y _2609_/Q _2369_/Y _2610_/Q sky130_fd_sc_hd__o21ai_0
XFILLER_24_197 VGND VPWR VPWR VGND sky130_fd_sc_hd__decap_4
XFILLER_47_256 VPWR VGND VPWR VGND sky130_fd_sc_hd__decap_3
XFILLER_70_281 VPWR VGND VPWR VGND sky130_fd_sc_hd__decap_8
XFILLER_46_50 VPWR VGND VPWR VGND sky130_fd_sc_hd__decap_3
Xmax_cap40 VGND VPWR VPWR VGND _1474_/Y _1516_/B sky130_fd_sc_hd__clkdlybuf4s25_1
Xmax_cap73 VGND VPWR VPWR VGND _2108_/A _1550_/B sky130_fd_sc_hd__clkdlybuf4s25_1
XFILLER_30_167 VPWR VGND VPWR VGND sky130_fd_sc_hd__decap_8
Xhold308 _1936_/A _2545_/Q VPWR VGND VGND VPWR sky130_fd_sc_hd__dlygate4sd3_1
X_1671_ VPWR VGND VGND VPWR _2332_/A _2318_/A _1671_/Y _1671_/C sky130_fd_sc_hd__nand3_1
X_1740_ VPWR VGND VGND VPWR _1740_/A _1741_/B _1740_/B sky130_fd_sc_hd__nand2_1
Xhold319 _2004_/A _2584_/Q VPWR VGND VGND VPWR sky130_fd_sc_hd__dlygate4sd3_1
XFILLER_30_3 VGND VPWR VPWR VGND sky130_fd_sc_hd__decap_4
X_2223_ VPWR VGND VGND VPWR _2229_/B _2222_/X _2224_/A2 _2223_/X sky130_fd_sc_hd__o21a_1
XFILLER_38_267 VPWR VGND VPWR VGND sky130_fd_sc_hd__decap_3
X_2085_ VPWR VGND VGND VPWR _1264_/A _2080_/Y _2083_/X _1262_/C _2411_/D sky130_fd_sc_hd__o22ai_1
X_2154_ VPWR VGND VPWR VGND _2486_/Q _2330_/B _1371_/B _2155_/A sky130_fd_sc_hd__a21oi_1
XFILLER_21_101 VPWR VGND VPWR VGND sky130_fd_sc_hd__decap_3
X_1869_ VPWR VGND VGND VPWR _1867_/A _1869_/Y _2028_/A _1944_/S sky130_fd_sc_hd__mux2i_1
X_1938_ VPWR VGND VGND VPWR _2545_/Q _1938_/Y _2571_/Q _1944_/S sky130_fd_sc_hd__mux2i_1
XFILLER_29_201 VGND VPWR VPWR VGND sky130_fd_sc_hd__decap_12
XFILLER_12_101 VGND VPWR VPWR VGND sky130_fd_sc_hd__decap_12
XFILLER_32_85 VGND VPWR VPWR VGND sky130_fd_sc_hd__decap_4
XFILLER_12_189 VPWR VGND VPWR VGND sky130_fd_sc_hd__decap_6
XFILLER_43_281 VPWR VGND VPWR VGND sky130_fd_sc_hd__decap_8
X_1654_ VGND VPWR VPWR VGND _1648_/Y _1657_/D _1657_/C _1654_/Y _1657_/B sky130_fd_sc_hd__a31oi_1
X_1723_ VPWR VGND VGND VPWR _1723_/X _1723_/C _2448_/Q _2390_/Q sky130_fd_sc_hd__maj3_1
X_2206_ VGND VPWR _2206_/B _2206_/Y _2206_/A VPWR VGND sky130_fd_sc_hd__xnor2_1
X_1585_ VPWR VGND VGND VPWR _2625_/Q _1585_/B _1586_/C sky130_fd_sc_hd__nor2_1
X_2137_ VPWR VGND VGND VPWR _2137_/A _2474_/Q _2191_/A sky130_fd_sc_hd__nor2_1
XFILLER_41_207 VPWR VGND VPWR VGND sky130_fd_sc_hd__decap_6
X_2068_ VGND VPWR VPWR VGND _2400_/D _2400_/Q _2076_/S _2458_/Q sky130_fd_sc_hd__mux2_1
XPHY_EDGE_ROW_14_Left_85 VPWR VGND VPWR VGND sky130_fd_sc_hd__decap_3
XFILLER_40_284 VGND VPWR VPWR VGND sky130_fd_sc_hd__decap_4
Xload_slew6 VPWR VGND _2067_/S _2060_/S VPWR VGND sky130_fd_sc_hd__buf_4
XFILLER_4_34 VPWR VGND VPWR VGND sky130_fd_sc_hd__decap_8
XFILLER_4_23 VGND VPWR VPWR VGND sky130_fd_sc_hd__decap_4
X_1370_ VPWR VGND VGND VPWR _2318_/A _2158_/B _1371_/B sky130_fd_sc_hd__nor2b_1
XFILLER_31_262 VGND VPWR VPWR VGND sky130_fd_sc_hd__decap_12
X_1637_ VPWR VGND VGND VPWR _2383_/A _1637_/Y _2463_/Q sky130_fd_sc_hd__nand2_1
X_1706_ VPWR VGND VPWR VGND _1671_/C _2318_/A _2332_/A _1707_/B sky130_fd_sc_hd__a21oi_1
X_1568_ VGND VPWR _2617_/Q _1569_/B _2618_/Q VPWR VGND sky130_fd_sc_hd__xnor2_1
X_1499_ VPWR VGND VPWR VGND _1497_/Y _2187_/B _1498_/Y _1500_/B sky130_fd_sc_hd__a21oi_1
Xfanout55 VGND VPWR VGND VPWR _1834_/Y _1975_/B sky130_fd_sc_hd__clkdlybuf4s50_1
Xfanout22 VGND VPWR VGND VPWR _2167_/X _2283_/B sky130_fd_sc_hd__clkdlybuf4s50_1
Xfanout44 VGND VPWR VGND VPWR _1942_/B _1933_/B sky130_fd_sc_hd__clkdlybuf4s50_1
Xfanout88 VGND VPWR VGND VPWR _2614_/Q _2034_/B sky130_fd_sc_hd__clkdlybuf4s50_1
Xfanout99 VGND VPWR VGND VPWR _2611_/Q _2379_/A sky130_fd_sc_hd__clkdlybuf4s50_1
XFILLER_13_32 VGND VPWR VPWR VGND sky130_fd_sc_hd__decap_4
Xfanout77 VGND VPWR VGND VPWR _2196_/B _1543_/B sky130_fd_sc_hd__clkdlybuf4s50_1
XFILLER_8_3 VGND VPWR VPWR VGND sky130_fd_sc_hd__decap_12
XFILLER_70_93 VPWR VGND VPWR VGND sky130_fd_sc_hd__decap_3
X_2471_ VGND VPWR VPWR VGND _2616_/CLK _2471_/D fanout190/X _2471_/Q sky130_fd_sc_hd__dfrtp_1
X_1422_ VGND VPWR _1422_/B _1440_/B wire36/X VPWR VGND sky130_fd_sc_hd__xnor2_1
X_2540_ VGND VPWR VPWR VGND clkload5/A _2540_/D load_slew154/X _2540_/Q sky130_fd_sc_hd__dfrtp_1
X_1284_ VPWR VGND VPWR VGND _2473_/Q _1275_/Y _1284_/Y _2474_/Q _1274_/Y sky130_fd_sc_hd__a22oi_1
X_1353_ VPWR VGND VGND VPWR _1352_/Y _1357_/B _2356_/A sky130_fd_sc_hd__nor2b_1
XFILLER_48_192 VGND VPWR VPWR VGND sky130_fd_sc_hd__decap_4
Xclkload8 clkload8/X clkload8/A VPWR VGND VGND VPWR sky130_fd_sc_hd__clkbuf_8
XFILLER_24_53 VPWR VGND VPWR VGND sky130_fd_sc_hd__decap_8
XFILLER_40_85 VPWR VGND VPWR VGND sky130_fd_sc_hd__decap_3
X_1971_ VPWR VGND VGND VPWR _2556_/Q _1971_/Y _2582_/Q _1971_/S sky130_fd_sc_hd__mux2i_1
XFILLER_60_3 VGND VPWR VPWR VGND sky130_fd_sc_hd__decap_12
X_2385_ VGND VPWR VPWR VGND clkload8/A _2385_/D load_slew172/X _2385_/Q sky130_fd_sc_hd__dfrtp_1
X_2523_ VGND VPWR VPWR VGND clkload6/A _2523_/D load_slew142/X _2523_/Q sky130_fd_sc_hd__dfrtp_1
X_2454_ VGND VPWR VPWR VGND clkload6/A _2454_/D fanout141/X _2454_/Q sky130_fd_sc_hd__dfrtp_1
X_1405_ VGND VPWR VGND VPWR _1407_/B _1445_/A _1417_/A2 _1406_/B _1379_/Y sky130_fd_sc_hd__o211a_1
Xinput1 VGND VPWR VGND VPWR rst_n input1/X sky130_fd_sc_hd__clkdlybuf4s50_1
X_1267_ VPWR VGND VGND VPWR _2198_/B _2185_/B _1472_/A sky130_fd_sc_hd__nor2_1
X_1198_ VPWR VGND VGND VPWR _2198_/B _2137_/A sky130_fd_sc_hd__inv_1
X_1336_ VGND VPWR VGND VPWR _1339_/A _1485_/A _1337_/B _1331_/B sky130_fd_sc_hd__o21ai_0
XFILLER_36_173 VPWR VGND VPWR VGND sky130_fd_sc_hd__decap_6
XFILLER_59_232 VPWR VGND VPWR VGND sky130_fd_sc_hd__decap_8
XPHY_EDGE_ROW_2_Left_73 VPWR VGND VPWR VGND sky130_fd_sc_hd__decap_3
X_2170_ VPWR VGND VPWR VGND _2171_/B _2283_/B _2171_/A _2173_/B sky130_fd_sc_hd__a21oi_1
X_1954_ VPWR VGND VGND VPWR _1954_/A _1954_/Y _1954_/B sky130_fd_sc_hd__nand2_1
X_1885_ VPWR VGND VGND VPWR _1885_/A _1885_/Y _1954_/B sky130_fd_sc_hd__nand2_1
X_2506_ VGND VPWR VPWR VGND _2607_/CLK _2506_/D fanout187/X _2506_/Q sky130_fd_sc_hd__dfrtp_1
X_2437_ VPWR VGND VPWR VGND _2437_/Q _2437_/SET_B _2437_/D clkload4/A sky130_fd_sc_hd__dfstp_2
X_2368_ VPWR VGND VPWR VGND _1454_/X _2610_/Q _1466_/B _2368_/Y sky130_fd_sc_hd__a21oi_1
X_1319_ VGND VPWR VGND VPWR _1315_/Y _1519_/A _1320_/B _2272_/B sky130_fd_sc_hd__o21ai_0
X_2299_ VPWR VGND VGND VPWR _2360_/A _2286_/Y _2297_/Y _2298_/Y _2299_/Y sky130_fd_sc_hd__o22ai_1
XFILLER_47_202 VPWR VGND VPWR VGND sky130_fd_sc_hd__decap_3
XFILLER_46_40 VPWR VGND VPWR VGND sky130_fd_sc_hd__decap_6
Xmax_cap74 VGND VPWR _1477_/B _1496_/A VPWR VGND sky130_fd_sc_hd__buf_1
Xmax_cap41 VGND VPWR VPWR VGND _1315_/B _1340_/B sky130_fd_sc_hd__clkdlybuf4s25_1
Xhold309 _2024_/A _2594_/Q VPWR VGND VGND VPWR sky130_fd_sc_hd__dlygate4sd3_1
X_1670_ VPWR VGND VGND VPWR _2307_/A _1702_/B _1671_/C sky130_fd_sc_hd__nor2_1
X_2222_ VGND VPWR _2222_/X _2222_/B _2222_/A _2222_/C VPWR VGND sky130_fd_sc_hd__and3_1
XFILLER_23_3 VGND VPWR VPWR VGND sky130_fd_sc_hd__decap_4
X_2084_ VPWR VGND VPWR VGND _2079_/Y _1218_/Y _2083_/X _2410_/D sky130_fd_sc_hd__a21oi_1
X_2153_ VPWR VGND VGND VPWR _2273_/A _2149_/B _2153_/Y _2305_/B _2151_/Y _2152_/Y
+ sky130_fd_sc_hd__o221ai_1
X_1937_ VGND VPWR VGND VPWR _1936_/Y _1942_/B _2545_/D _1935_/Y sky130_fd_sc_hd__o21ai_0
X_1799_ VPWR VGND VPWR VGND _1798_/C _2497_/Q hold343/X _1799_/Y sky130_fd_sc_hd__a21oi_1
X_1868_ VGND VPWR VGND VPWR _1867_/Y _1933_/B _2522_/D _1866_/Y sky130_fd_sc_hd__o21ai_0
XFILLER_29_213 VPWR VGND VPWR VGND sky130_fd_sc_hd__decap_8
XFILLER_32_42 VGND VPWR VPWR VGND sky130_fd_sc_hd__decap_4
X_1584_ VGND VPWR _1589_/C _2624_/Q _2625_/Q _1584_/C VPWR VGND sky130_fd_sc_hd__and3_1
X_1722_ VGND VPWR VGND VPWR _1715_/Y _1720_/X _1723_/C _1721_/Y sky130_fd_sc_hd__o21ai_0
XPHY_EDGE_ROW_9_Right_9 VPWR VGND VPWR VGND sky130_fd_sc_hd__decap_3
X_1653_ VGND VPWR VPWR VGND _1651_/Y _1650_/Y _1657_/D _2468_/D _1652_/Y sky130_fd_sc_hd__a31oi_1
X_2205_ VPWR VGND VGND VPWR _2206_/A _2222_/B _2206_/B sky130_fd_sc_hd__nand2_1
X_2136_ VPWR VGND VGND VPWR _2136_/A _2136_/Y _2136_/B sky130_fd_sc_hd__nand2_1
X_2067_ VGND VPWR VPWR VGND _2399_/D _2399_/Q _2067_/S _2457_/Q sky130_fd_sc_hd__mux2_1
XFILLER_40_263 VGND VPWR VPWR VGND sky130_fd_sc_hd__decap_4
XFILLER_4_197 VPWR VGND VPWR VGND sky130_fd_sc_hd__decap_8
XFILLER_23_208 VGND VPWR VPWR VGND sky130_fd_sc_hd__decap_12
XFILLER_31_274 VPWR VGND VPWR VGND sky130_fd_sc_hd__decap_6
X_1705_ VGND VPWR VPWR VGND _1671_/C _2318_/A _2333_/A _2485_/D _1704_/Y sky130_fd_sc_hd__a31oi_1
X_1567_ VPWR VGND VGND VPWR _1567_/A _1977_/B _2617_/D sky130_fd_sc_hd__nor2_1
X_1636_ VPWR VGND VGND VPWR _1242_/Y _2461_/D _1635_/Y _1638_/S sky130_fd_sc_hd__mux2i_1
X_1498_ VPWR VGND VGND VPWR _2187_/B _2171_/A _2619_/Q _2201_/B _1498_/Y sky130_fd_sc_hd__o22ai_1
X_2119_ VPWR VGND VPWR VGND _2119_/A _2119_/C _2119_/D _2122_/A _2119_/B sky130_fd_sc_hd__nand4_1
Xfanout78 VGND VPWR VGND VPWR _2196_/B _2136_/A sky130_fd_sc_hd__clkdlybuf4s50_1
Xfanout67 VGND VPWR VGND VPWR _1974_/S _1965_/S sky130_fd_sc_hd__clkdlybuf4s50_1
Xfanout23 VGND VPWR VGND VPWR _2167_/X _2224_/A2 sky130_fd_sc_hd__clkdlybuf4s50_1
Xfanout89 VGND VPWR VGND VPWR _2042_/B _2038_/B sky130_fd_sc_hd__clkdlybuf4s50_1
Xfanout12 VGND VPWR VGND VPWR _2380_/S _1638_/S sky130_fd_sc_hd__clkdlybuf4s50_1
Xfanout45 VGND VPWR VGND VPWR _1930_/B _1942_/B sky130_fd_sc_hd__clkdlybuf4s50_1
XFILLER_13_241 VPWR VGND VPWR VGND sky130_fd_sc_hd__decap_8
X_2470_ VGND VPWR VPWR VGND clkload5/A _2470_/D load_slew162/X _2470_/Q sky130_fd_sc_hd__dfrtp_1
X_1421_ VGND VPWR VPWR VGND _1442_/C _1421_/X _1421_/B sky130_fd_sc_hd__xor2_1
X_1283_ VGND VPWR VGND VPWR _1282_/X _2473_/Q _1283_/Y _1275_/Y sky130_fd_sc_hd__o21ai_0
X_1352_ VPWR VGND VGND VPWR _2159_/A _1352_/Y _2158_/B sky130_fd_sc_hd__nand2_1
Xclkload9 VGND VPWR VPWR VGND clkload9/A clkload9/Y sky130_fd_sc_hd__clkinv_2
X_2599_ VGND VPWR VPWR VGND clkload2/A _2599_/D fanout156/X _2599_/Q sky130_fd_sc_hd__dfrtp_1
X_1619_ VPWR VGND VGND VPWR _1627_/A _1619_/Y _2454_/Q sky130_fd_sc_hd__nand2_1
XFILLER_40_64 VPWR VGND VPWR VGND sky130_fd_sc_hd__decap_8
XFILLER_6_237 VGND VPWR VPWR VGND sky130_fd_sc_hd__decap_4
XFILLER_65_50 VPWR VGND VPWR VGND sky130_fd_sc_hd__decap_6
XFILLER_49_51 VGND VPWR VPWR VGND sky130_fd_sc_hd__decap_4
X_1970_ VGND VPWR VGND VPWR _1969_/Y _1969_/B _1970_/Y _1968_/Y sky130_fd_sc_hd__o21ai_0
XFILLER_60_122 VPWR VGND VPWR VGND sky130_fd_sc_hd__decap_6
XFILLER_45_174 VGND VPWR VPWR VGND sky130_fd_sc_hd__decap_12
XFILLER_53_3 VPWR VGND VPWR VGND sky130_fd_sc_hd__decap_8
X_2522_ VGND VPWR VPWR VGND clkload6/A _2522_/D load_slew142/X _2522_/Q sky130_fd_sc_hd__dfrtp_1
X_2384_ VPWR VGND VGND VPWR _1238_/Y _2446_/D _2383_/Y _2384_/S sky130_fd_sc_hd__mux2i_1
X_1335_ VGND VPWR VPWR VGND _1484_/A _1339_/C _2272_/A sky130_fd_sc_hd__xor2_1
XFILLER_5_281 VPWR VGND VPWR VGND sky130_fd_sc_hd__decap_8
X_2453_ VGND VPWR VPWR VGND clkload6/A _2453_/D load_slew144/X _2453_/Q sky130_fd_sc_hd__dfrtp_1
X_1404_ VPWR VGND VGND VPWR _2436_/Q _1406_/B _2273_/A sky130_fd_sc_hd__nand2_1
Xinput2 VGND VPWR VGND VPWR spdif_in input2/X sky130_fd_sc_hd__clkdlybuf4s50_1
X_1266_ VPWR VGND VGND VPWR _2198_/B _1266_/Y _2185_/B sky130_fd_sc_hd__nand2_1
X_1197_ VPWR VGND VGND VPWR _2176_/A _2212_/B sky130_fd_sc_hd__inv_1
XFILLER_18_141 VPWR VGND VPWR VGND sky130_fd_sc_hd__decap_6
X_1884_ VPWR VGND VGND VPWR _2527_/Q _1884_/Y _2601_/Q _1884_/S sky130_fd_sc_hd__mux2i_1
X_1953_ VPWR VGND VGND VPWR _2550_/Q _1953_/Y _2576_/Q _1956_/S sky130_fd_sc_hd__mux2i_1
XFILLER_33_133 VPWR VGND VPWR VGND sky130_fd_sc_hd__decap_3
X_2505_ VGND VPWR VPWR VGND _2607_/CLK _2505_/D fanout178/X i2s_sd sky130_fd_sc_hd__dfrtp_1
X_1318_ VGND VPWR VPWR VGND _1486_/A _1340_/C _2287_/B sky130_fd_sc_hd__xor2_1
X_2436_ VPWR VGND VPWR VGND _2436_/Q fanout159/X _2436_/D clkload4/A sky130_fd_sc_hd__dfstp_2
X_2367_ VPWR VGND VPWR VGND _2438_/D fanout3/X _2364_/Y _2366_/Y _2331_/B _2096_/A
+ sky130_fd_sc_hd__o32a_1
X_2298_ VGND VPWR VGND VPWR _2360_/A _2287_/B _2298_/Y _2167_/X sky130_fd_sc_hd__o21ai_0
X_1249_ VPWR VGND VGND VPWR _2497_/Q _1810_/A sky130_fd_sc_hd__inv_1
Xmax_cap42 VGND VPWR VPWR VGND wire43/X _1315_/B sky130_fd_sc_hd__clkdlybuf4s25_1
Xmax_cap20 VGND VPWR _2052_/B _1651_/C VPWR VGND sky130_fd_sc_hd__buf_1
Xmax_cap31 VGND VPWR VPWR VGND wire32/X _1417_/A2 sky130_fd_sc_hd__clkdlybuf4s25_1
X_2221_ VPWR VGND VPWR VGND _2222_/B _2222_/A _2222_/C _2229_/B sky130_fd_sc_hd__a21oi_1
X_2152_ VPWR VGND VGND VPWR _2481_/Q _2152_/Y _2152_/B sky130_fd_sc_hd__nand2_1
X_2083_ VGND VPWR VPWR VGND _2083_/X _2082_/Y _2080_/D _2083_/B1 _2080_/B _2101_/A
+ sky130_fd_sc_hd__o2111a_1
X_1936_ VPWR VGND VGND VPWR _1936_/A _1936_/Y _1942_/B sky130_fd_sc_hd__nand2_1
X_1867_ VPWR VGND VGND VPWR _1867_/A _1867_/Y _1933_/B sky130_fd_sc_hd__nand2_1
X_1798_ VGND VPWR _1805_/D _2498_/Q _2497_/Q _1798_/C VPWR VGND sky130_fd_sc_hd__and3_1
XFILLER_29_225 VPWR VGND VPWR VGND sky130_fd_sc_hd__decap_3
X_2419_ VGND VPWR VPWR VGND _2592_/CLK _2419_/D _2437_/SET_B _2419_/Q sky130_fd_sc_hd__dfrtp_1
XFILLER_12_136 VGND VPWR VPWR VGND sky130_fd_sc_hd__decap_4
XFILLER_8_129 VPWR VGND VPWR VGND sky130_fd_sc_hd__decap_8
XFILLER_43_261 VPWR VGND VPWR VGND sky130_fd_sc_hd__decap_6
XPHY_EDGE_ROW_35_Left_106 VPWR VGND VPWR VGND sky130_fd_sc_hd__decap_3
X_1721_ VPWR VGND VGND VPWR _2447_/Q _2389_/Q _2446_/Q _2388_/Q _1721_/Y sky130_fd_sc_hd__o22ai_1
X_1583_ VPWR VGND VGND VPWR _1583_/C _1585_/B _1603_/A _2624_/D sky130_fd_sc_hd__nor3_1
XPHY_EDGE_ROW_44_Left_115 VPWR VGND VPWR VGND sky130_fd_sc_hd__decap_3
X_1652_ VPWR VGND VGND VPWR _2468_/Q _1657_/D _1652_/Y sky130_fd_sc_hd__nor2_1
X_2204_ VGND VPWR VGND VPWR _2189_/Y _2190_/A _2206_/B _2192_/B sky130_fd_sc_hd__o21ai_0
XPHY_EDGE_ROW_53_Left_124 VPWR VGND VPWR VGND sky130_fd_sc_hd__decap_3
X_2135_ VGND VPWR VGND VPWR _2136_/B _1454_/X _1565_/Y _1221_/Y _2167_/A sky130_fd_sc_hd__a211o_1
XFILLER_26_217 VGND VPWR VPWR VGND sky130_fd_sc_hd__decap_12
X_2066_ VGND VPWR VPWR VGND _2398_/D _2398_/Q _2067_/S _2456_/Q sky130_fd_sc_hd__mux2_1
XPHY_EDGE_ROW_62_Left_133 VPWR VGND VPWR VGND sky130_fd_sc_hd__decap_3
X_1919_ VGND VPWR VGND VPWR _1918_/Y _1948_/B _1919_/Y _1917_/Y sky130_fd_sc_hd__o21ai_0
Xload_slew8 VPWR VGND _2074_/S _2054_/S VPWR VGND sky130_fd_sc_hd__buf_4
XFILLER_4_176 VPWR VGND VPWR VGND sky130_fd_sc_hd__decap_3
XFILLER_4_132 VPWR VGND VPWR VGND sky130_fd_sc_hd__decap_8
XFILLER_67_117 VPWR VGND VPWR VGND sky130_fd_sc_hd__decap_3
X_1704_ VGND VPWR VGND VPWR _1466_/B _2318_/A _1704_/Y _1671_/C sky130_fd_sc_hd__o21ai_0
X_1497_ VPWR VGND VPWR VGND _2617_/Q _1201_/Y _2618_/Q _1497_/Y sky130_fd_sc_hd__a21oi_1
X_1635_ VPWR VGND VGND VPWR _2383_/A _1635_/Y _2462_/Q sky130_fd_sc_hd__nand2_1
X_1566_ VPWR VGND VPWR VGND _1560_/Y _2470_/Q _1559_/Y _2608_/D _1557_/A sky130_fd_sc_hd__a22o_1
X_2118_ VPWR VGND VGND VPWR _2130_/B _2408_/Q _2466_/Q _2407_/Q _2465_/Q sky130_fd_sc_hd__nor4_1
X_2049_ VPWR VGND VPWR VGND _2050_/B _1246_/Y _2048_/Y _2606_/D sky130_fd_sc_hd__a21oi_1
Xfanout79 VGND VPWR VGND VPWR _1459_/X _2196_/B sky130_fd_sc_hd__clkdlybuf4s50_1
Xfanout46 VGND VPWR VGND VPWR _1924_/B _1930_/B sky130_fd_sc_hd__clkdlybuf4s50_1
XFILLER_54_85 VPWR VGND VPWR VGND sky130_fd_sc_hd__decap_8
XFILLER_9_268 VGND VPWR VPWR VGND sky130_fd_sc_hd__decap_12
X_1420_ VGND VPWR _1421_/B _1420_/Y _1442_/C VPWR VGND sky130_fd_sc_hd__xnor2_1
X_1351_ VPWR VGND VGND VPWR _2159_/A _2158_/B _1357_/B sky130_fd_sc_hd__nor2_1
X_1282_ VPWR VGND VGND VPWR _1282_/X _1282_/C _2472_/Q _1282_/B sky130_fd_sc_hd__maj3_1
X_1618_ VPWR VGND VGND VPWR _1232_/Y _2452_/D _1617_/Y _1624_/S sky130_fd_sc_hd__mux2i_1
X_1549_ VPWR VGND VGND VPWR _2108_/A _2417_/Q _2416_/Q _2415_/Q _2414_/Q sky130_fd_sc_hd__nor4_1
X_2598_ VGND VPWR VPWR VGND clkload1/A _2598_/D load_slew152/X _2598_/Q sky130_fd_sc_hd__dfrtp_1
XFILLER_54_197 VGND VPWR VPWR VGND sky130_fd_sc_hd__decap_4
Xhold290 _2561_/D _1981_/X VPWR VGND VGND VPWR sky130_fd_sc_hd__dlygate4sd3_1
X_2521_ VGND VPWR VPWR VGND clkload6/A _2521_/D load_slew142/X _2521_/Q sky130_fd_sc_hd__dfrtp_1
X_2383_ VPWR VGND VGND VPWR _2383_/A _2383_/Y _2447_/Q sky130_fd_sc_hd__nand2_1
X_1334_ VGND VPWR VGND VPWR _1333_/Y _1321_/Y _1334_/Y _1323_/Y sky130_fd_sc_hd__o21ai_0
X_1265_ VPWR VGND VPWR VGND _2082_/B _1265_/C _2411_/Q _1651_/B sky130_fd_sc_hd__or3_1
X_2452_ VGND VPWR VPWR VGND clkload6/A _2452_/D load_slew144/X _2452_/Q sky130_fd_sc_hd__dfrtp_1
XPHY_EDGE_ROW_18_Right_18 VPWR VGND VPWR VGND sky130_fd_sc_hd__decap_3
X_1403_ VGND VPWR VPWR VGND wire32/A _1442_/C _1381_/X _2272_/A _2287_/B _1402_/Y
+ sky130_fd_sc_hd__a221oi_1
X_1196_ VPWR VGND VGND VPWR _2230_/B _1303_/A sky130_fd_sc_hd__inv_1
XPHY_EDGE_ROW_27_Right_27 VPWR VGND VPWR VGND sky130_fd_sc_hd__decap_3
XPHY_EDGE_ROW_36_Right_36 VPWR VGND VPWR VGND sky130_fd_sc_hd__decap_3
XFILLER_27_153 VGND VPWR VPWR VGND sky130_fd_sc_hd__decap_4
XPHY_EDGE_ROW_45_Right_45 VPWR VGND VPWR VGND sky130_fd_sc_hd__decap_3
XFILLER_42_189 VPWR VGND VPWR VGND sky130_fd_sc_hd__decap_6
XFILLER_42_156 VGND VPWR VPWR VGND sky130_fd_sc_hd__decap_12
XPHY_EDGE_ROW_54_Right_54 VPWR VGND VPWR VGND sky130_fd_sc_hd__decap_3
XFILLER_51_53 VPWR VGND VPWR VGND sky130_fd_sc_hd__decap_3
XPHY_EDGE_ROW_63_Right_63 VPWR VGND VPWR VGND sky130_fd_sc_hd__decap_3
XFILLER_18_197 VGND VPWR VPWR VGND sky130_fd_sc_hd__decap_4
X_1883_ VGND VPWR VGND VPWR _1882_/Y _1951_/B _1883_/Y _1881_/Y sky130_fd_sc_hd__o21ai_0
X_1952_ VGND VPWR VGND VPWR _1951_/Y _1951_/B _2550_/D _1950_/Y sky130_fd_sc_hd__o21ai_0
X_2504_ VGND VPWR VPWR VGND _2633_/CLK _2504_/D fanout187/A _2504_/Q sky130_fd_sc_hd__dfrtp_1
X_2435_ VPWR VGND VPWR VGND _2435_/Q fanout157/A _2435_/D clkload3/A sky130_fd_sc_hd__dfstp_2
X_1248_ VPWR VGND VGND VPWR _2496_/Q _1809_/A sky130_fd_sc_hd__inv_1
X_1317_ VPWR VGND VGND VPWR _2478_/Q _1311_/X _1322_/B _1690_/A _1317_/Y sky130_fd_sc_hd__o22ai_1
X_2297_ VPWR VGND VGND VPWR _2297_/A _2297_/B _2297_/Y sky130_fd_sc_hd__nor2_1
X_2366_ VPWR VGND VPWR VGND _2286_/S _2333_/A _2365_/Y _2366_/Y sky130_fd_sc_hd__a21oi_1
XFILLER_47_248 VPWR VGND VPWR VGND sky130_fd_sc_hd__decap_8
XFILLER_70_273 VPWR VGND VPWR VGND sky130_fd_sc_hd__decap_6
X_2220_ VGND VPWR _2220_/B _2222_/C _2220_/A VPWR VGND sky130_fd_sc_hd__xnor2_1
X_2082_ VPWR VGND VGND VPWR _2082_/A _2082_/Y _2082_/B sky130_fd_sc_hd__nand2_1
X_2151_ VPWR VGND VGND VPWR _2151_/Y _1519_/A _2480_/Q _2152_/B _2150_/Y _2148_/Y
+ sky130_fd_sc_hd__o2111ai_1
XFILLER_53_218 VPWR VGND VPWR VGND sky130_fd_sc_hd__decap_6
X_1797_ VGND VPWR _1798_/C _2497_/D _1810_/A VPWR VGND sky130_fd_sc_hd__xnor2_1
X_1866_ VPWR VGND VGND VPWR _2521_/Q _1866_/Y _2595_/Q _1926_/S sky130_fd_sc_hd__mux2i_1
X_1935_ VPWR VGND VGND VPWR _2544_/Q _1935_/Y _2570_/Q _1944_/S sky130_fd_sc_hd__mux2i_1
X_2418_ VGND VPWR VPWR VGND _2592_/CLK _2418_/D _2437_/SET_B _2418_/Q sky130_fd_sc_hd__dfrtp_1
X_2349_ VPWR VGND VGND VPWR _2349_/A _2350_/B _2349_/B sky130_fd_sc_hd__nand2_1
XFILLER_52_240 VPWR VGND VPWR VGND sky130_fd_sc_hd__decap_3
XPHY_EDGE_ROW_0_Right_0 VPWR VGND VPWR VGND sky130_fd_sc_hd__decap_3
XFILLER_12_148 VGND VPWR VPWR VGND sky130_fd_sc_hd__decap_4
XFILLER_20_170 VGND VPWR VPWR VGND sky130_fd_sc_hd__decap_4
X_1720_ _1720_/X _1716_/Y _2128_/A _2128_/B _1719_/Y VPWR VGND VGND VPWR sky130_fd_sc_hd__o31a_1
X_1651_ VPWR VGND VGND VPWR _2468_/Q _1651_/B _1651_/Y _1651_/C sky130_fd_sc_hd__nand3_1
X_1582_ VPWR VGND VGND VPWR _2624_/Q _1584_/C _1583_/C sky130_fd_sc_hd__nor2_1
X_2203_ VGND VPWR _2203_/B _2206_/A _2203_/A VPWR VGND sky130_fd_sc_hd__xnor2_1
X_2065_ VGND VPWR VPWR VGND _2397_/D _2397_/Q _2067_/S _2455_/Q sky130_fd_sc_hd__mux2_1
XFILLER_19_281 VPWR VGND VPWR VGND sky130_fd_sc_hd__decap_8
X_2134_ VPWR VGND VPWR VGND _2133_/Y _1657_/C _2132_/Y _2422_/D sky130_fd_sc_hd__a21oi_1
XFILLER_26_229 VGND VPWR VPWR VGND sky130_fd_sc_hd__decap_4
X_1918_ VPWR VGND VGND VPWR _1918_/A _1918_/Y _1948_/B sky130_fd_sc_hd__nand2_1
X_1849_ VPWR VGND VGND VPWR _1849_/A _1849_/Y _1945_/B sky130_fd_sc_hd__nand2_1
XFILLER_43_32 VGND VPWR VPWR VGND sky130_fd_sc_hd__decap_4
X_1634_ VPWR VGND VGND VPWR _1224_/Y _2460_/D _1633_/Y _1638_/S sky130_fd_sc_hd__mux2i_1
X_1703_ VPWR VGND VPWR VGND _1702_/Y _1672_/C _2327_/B _2484_/D sky130_fd_sc_hd__a21oi_1
Xclkbuf_leaf_11_clk VGND VPWR VGND VPWR clkbuf_leaf_9_clk/A clkload5/A sky130_fd_sc_hd__clkbuf_16
X_1496_ VPWR VGND VGND VPWR _1496_/C _1570_/B _1496_/A _1500_/A sky130_fd_sc_hd__nor3_1
XFILLER_58_118 VPWR VGND VPWR VGND sky130_fd_sc_hd__decap_6
X_1565_ VPWR VGND VGND VPWR _2082_/A _1565_/Y _2470_/Q sky130_fd_sc_hd__nand2_1
XPHY_EDGE_ROW_18_Left_89 VPWR VGND VPWR VGND sky130_fd_sc_hd__decap_3
X_2048_ VPWR VGND VGND VPWR _2048_/A _2050_/B _2048_/Y sky130_fd_sc_hd__nor2_1
X_2117_ VPWR VGND VPWR VGND _2114_/X hold353/X _2101_/Y _2420_/D sky130_fd_sc_hd__a21o_1
Xfanout69 VGND VPWR VGND VPWR _1947_/S _1974_/S sky130_fd_sc_hd__clkdlybuf4s50_1
Xfanout47 VGND VPWR VGND VPWR _1948_/B _1945_/B sky130_fd_sc_hd__clkdlybuf4s50_1
Xfanout14 VGND VPWR VGND VPWR _1606_/X _2380_/S sky130_fd_sc_hd__clkdlybuf4s50_1
XFILLER_13_57 VPWR VGND VPWR VGND sky130_fd_sc_hd__decap_6
Xfanout25 VGND VPWR VGND VPWR _2286_/S _2359_/S sky130_fd_sc_hd__clkdlybuf4s50_1
XFILLER_57_151 VGND VPWR VPWR VGND sky130_fd_sc_hd__decap_4
XFILLER_38_98 VPWR VGND VPWR VGND sky130_fd_sc_hd__decap_6
XFILLER_1_169 VGND VPWR VPWR VGND sky130_fd_sc_hd__decap_4
XFILLER_54_42 VPWR VGND VPWR VGND sky130_fd_sc_hd__decap_3
XFILLER_70_41 VGND VPWR VPWR VGND sky130_fd_sc_hd__decap_4
X_1281_ VPWR VGND VGND VPWR _1389_/B _1282_/C _1432_/B _1431_/B sky130_fd_sc_hd__mux2i_1
X_1350_ VPWR VGND VPWR VGND _1347_/Y _2483_/Q _1349_/Y _1350_/X sky130_fd_sc_hd__a21o_1
XFILLER_63_165 VPWR VGND VPWR VGND sky130_fd_sc_hd__decap_3
Xclkbuf_leaf_0_clk VGND VPWR VGND VPWR clkbuf_leaf_9_clk/A clkload1/A sky130_fd_sc_hd__clkbuf_16
X_1617_ VPWR VGND VGND VPWR _1627_/A _1617_/Y _2453_/Q sky130_fd_sc_hd__nand2_1
X_2597_ VGND VPWR VPWR VGND clkload1/A _2597_/D load_slew150/X _2597_/Q sky130_fd_sc_hd__dfrtp_1
X_1479_ VPWR VGND VGND VPWR _2241_/B _1512_/B _1507_/A sky130_fd_sc_hd__nand2_1
X_1548_ VPWR VGND VGND VPWR _2416_/Q _2415_/Q _2414_/Q _2105_/A sky130_fd_sc_hd__nor3_1
Xhold291 _1855_/A _2518_/Q VPWR VGND VGND VPWR sky130_fd_sc_hd__dlygate4sd3_1
Xhold280 hold280/X _2567_/Q VPWR VGND VGND VPWR sky130_fd_sc_hd__dlygate4sd3_1
X_1402_ VPWR VGND VGND VPWR _1421_/B _1443_/A _1402_/Y sky130_fd_sc_hd__nor2_1
XFILLER_5_261 VGND VPWR VPWR VGND sky130_fd_sc_hd__decap_12
X_2520_ VGND VPWR VPWR VGND clkload6/A _2520_/D load_slew142/X _2520_/Q sky130_fd_sc_hd__dfrtp_1
X_2451_ VGND VPWR VPWR VGND clkload6/A _2451_/D load_slew147/X _2451_/Q sky130_fd_sc_hd__dfrtp_1
X_2382_ VPWR VGND VGND VPWR _1239_/Y _2445_/D _2381_/Y _2384_/S sky130_fd_sc_hd__mux2i_1
XFILLER_39_3 VGND VPWR VPWR VGND sky130_fd_sc_hd__decap_12
X_1333_ VPWR VGND VPWR VGND _1321_/B _1692_/A _1332_/Y _1333_/Y sky130_fd_sc_hd__a21oi_1
X_1264_ VPWR VGND VGND VPWR _1264_/A _1265_/C _2077_/B sky130_fd_sc_hd__nor2_1
XFILLER_51_113 VPWR VGND VPWR VGND sky130_fd_sc_hd__decap_3
X_1195_ VPWR VGND VGND VPWR _2242_/B _2241_/B sky130_fd_sc_hd__inv_1
XFILLER_36_187 VPWR VGND VPWR VGND sky130_fd_sc_hd__decap_3
XFILLER_59_202 VGND VPWR VPWR VGND sky130_fd_sc_hd__decap_4
XFILLER_50_190 VPWR VGND VPWR VGND sky130_fd_sc_hd__decap_6
XFILLER_42_168 VGND VPWR VPWR VGND sky130_fd_sc_hd__decap_12
XFILLER_65_238 VPWR VGND VPWR VGND sky130_fd_sc_hd__decap_6
XFILLER_41_190 VPWR VGND VPWR VGND sky130_fd_sc_hd__decap_6
X_1882_ VPWR VGND VGND VPWR _1882_/A _1882_/Y _1951_/B sky130_fd_sc_hd__nand2_1
X_1951_ VPWR VGND VGND VPWR _1951_/A _1951_/Y _1951_/B sky130_fd_sc_hd__nand2_1
X_2503_ VGND VPWR VPWR VGND _2634_/CLK _2503_/D load_slew175/X pwm_out sky130_fd_sc_hd__dfrtp_1
X_2434_ VPWR VGND VPWR VGND _2434_/Q fanout159/X _2434_/D clkload4/A sky130_fd_sc_hd__dfstp_2
X_2365_ VGND VPWR VGND VPWR _2365_/B1 _2331_/B _2365_/Y _2359_/S sky130_fd_sc_hd__o21ai_0
X_1247_ VPWR VGND VGND VPWR _2466_/Q _1247_/Y sky130_fd_sc_hd__inv_1
X_1316_ VGND VPWR wire43/X _1322_/B _1340_/A VPWR VGND sky130_fd_sc_hd__xnor2_1
X_2296_ VGND VPWR _2296_/B _2297_/B _2296_/A VPWR VGND sky130_fd_sc_hd__xnor2_1
XFILLER_21_57 VGND VPWR VPWR VGND sky130_fd_sc_hd__decap_12
Xmax_cap33 VGND VPWR VPWR VGND _2264_/B _2281_/A2 sky130_fd_sc_hd__clkdlybuf4s25_1
XPHY_EDGE_ROW_6_Left_77 VPWR VGND VPWR VGND sky130_fd_sc_hd__decap_3
XFILLER_38_205 VPWR VGND VPWR VGND sky130_fd_sc_hd__decap_3
X_2081_ VGND VPWR VPWR VGND _1219_/Y _2080_/Y _2079_/Y _2409_/D sky130_fd_sc_hd__a21boi_0
X_2150_ VGND VPWR _2481_/Q _2150_/Y _2305_/B VPWR VGND sky130_fd_sc_hd__xnor2_1
X_1934_ VGND VPWR VGND VPWR _1933_/Y _1933_/B _1934_/Y _1932_/Y sky130_fd_sc_hd__o21ai_0
X_1796_ VPWR VGND VGND VPWR _1798_/C _1796_/B _2496_/D sky130_fd_sc_hd__nor2_1
X_1865_ VGND VPWR VGND VPWR _1864_/Y _1933_/B _2521_/D _1863_/Y sky130_fd_sc_hd__o21ai_0
X_2348_ VPWR VGND VGND VPWR _2348_/A _2350_/A _2348_/B sky130_fd_sc_hd__nand2_1
X_2417_ VGND VPWR VPWR VGND clkload4/A _2417_/D _2437_/SET_B _2417_/Q sky130_fd_sc_hd__dfrtp_1
XFILLER_37_271 VPWR VGND VPWR VGND sky130_fd_sc_hd__decap_8
X_2279_ VGND VPWR _2279_/B _2282_/A _2279_/A VPWR VGND sky130_fd_sc_hd__xnor2_1
XFILLER_16_24 VGND VPWR VPWR VGND sky130_fd_sc_hd__decap_4
XFILLER_32_56 VPWR VGND VPWR VGND sky130_fd_sc_hd__decap_3
XFILLER_32_23 VGND VPWR VPWR VGND sky130_fd_sc_hd__decap_4
XFILLER_43_274 VPWR VGND VPWR VGND sky130_fd_sc_hd__decap_6
X_1581_ VGND VPWR VPWR VGND _1585_/B _1584_/C _2624_/Q sky130_fd_sc_hd__and2_0
X_1650_ VPWR VGND VGND VPWR _1657_/C _1650_/Y _1650_/B sky130_fd_sc_hd__nand2_1
X_2202_ VPWR VGND VGND VPWR _2203_/B _2203_/A _2222_/A sky130_fd_sc_hd__nand2b_1
XFILLER_21_3 VPWR VGND VPWR VGND sky130_fd_sc_hd__decap_8
X_2064_ VGND VPWR VPWR VGND _2396_/D _2396_/Q _2067_/S _2454_/Q sky130_fd_sc_hd__mux2_1
X_2133_ VPWR VGND VPWR VGND _2133_/Y _2375_/B _1561_/B locked _1255_/Y sky130_fd_sc_hd__a211oi_1
X_1917_ VPWR VGND VGND VPWR _2538_/Q _1917_/Y _2564_/Q _1917_/S sky130_fd_sc_hd__mux2i_1
X_1779_ VPWR VGND VPWR VGND _1777_/Y _1999_/S _1778_/Y _2491_/D sky130_fd_sc_hd__a21oi_1
X_1848_ VPWR VGND VGND VPWR _2515_/Q _1848_/Y _2589_/Q _1932_/S sky130_fd_sc_hd__mux2i_1
XFILLER_17_219 VGND VPWR VPWR VGND sky130_fd_sc_hd__decap_4
XPHY_EDGE_ROW_9_Left_80 VPWR VGND VPWR VGND sky130_fd_sc_hd__decap_3
XFILLER_69_3 VPWR VGND VPWR VGND sky130_fd_sc_hd__decap_6
X_1633_ VPWR VGND VGND VPWR _2383_/A _1633_/Y _2461_/Q sky130_fd_sc_hd__nand2_1
X_1702_ VGND VPWR _1702_/B _1702_/Y _2307_/A VPWR VGND sky130_fd_sc_hd__xnor2_1
X_1564_ VGND VPWR VPWR VGND _2609_/D _1543_/B _1455_/B hold362/X _1542_/Y _2609_/Q
+ sky130_fd_sc_hd__a32o_1
X_1495_ VPWR VGND VGND VPWR _2201_/B _1495_/B _1496_/C sky130_fd_sc_hd__nor2_1
X_2047_ VPWR VGND VPWR VGND _2050_/B _1245_/Y _2046_/Y _2605_/D sky130_fd_sc_hd__a21oi_1
Xfanout26 VGND VPWR VGND VPWR _2286_/S _2255_/B sky130_fd_sc_hd__clkdlybuf4s50_1
X_2116_ VPWR VGND VPWR VGND _2115_/Y _2114_/X _2101_/Y _2419_/D sky130_fd_sc_hd__a21oi_1
Xfanout48 VGND VPWR VGND VPWR _1924_/B _1948_/B sky130_fd_sc_hd__clkdlybuf4s50_1
XFILLER_22_244 VGND VPWR VPWR VGND sky130_fd_sc_hd__decap_4
XFILLER_54_65 VPWR VGND VPWR VGND sky130_fd_sc_hd__decap_3
X_1280_ VGND VPWR _2423_/Q _1432_/B _2185_/B VPWR VGND sky130_fd_sc_hd__xnor2_1
XFILLER_0_181 VGND VPWR VPWR VGND sky130_fd_sc_hd__decap_12
XFILLER_48_174 VPWR VGND VPWR VGND sky130_fd_sc_hd__decap_8
X_2596_ VGND VPWR VPWR VGND clkload6/A _2596_/D load_slew142/X _2596_/Q sky130_fd_sc_hd__dfrtp_1
X_1616_ VPWR VGND VGND VPWR _1233_/Y _2451_/D _1615_/Y _1624_/S sky130_fd_sc_hd__mux2i_1
X_1547_ VGND VPWR VGND VPWR hold362/X _1454_/X _1563_/A _1466_/B sky130_fd_sc_hd__o21ai_0
X_1478_ VPWR VGND VGND VPWR _2201_/A _1502_/B _1507_/A sky130_fd_sc_hd__nor2_1
XPHY_EDGE_ROW_59_Left_130 VPWR VGND VPWR VGND sky130_fd_sc_hd__decap_3
XFILLER_40_45 VGND VPWR VPWR VGND sky130_fd_sc_hd__decap_12
Xhold292 hold292/X _2575_/Q VPWR VGND VGND VPWR sky130_fd_sc_hd__dlygate4sd3_1
Xhold270 _2566_/D _1986_/X VPWR VGND VGND VPWR sky130_fd_sc_hd__dlygate4sd3_1
Xhold281 hold281/X _2574_/Q VPWR VGND VGND VPWR sky130_fd_sc_hd__dlygate4sd3_1
X_2381_ VPWR VGND VGND VPWR _2383_/A _2381_/Y _2446_/Q sky130_fd_sc_hd__nand2_1
X_1401_ VGND VPWR _2287_/B _1443_/A _2272_/A VPWR VGND sky130_fd_sc_hd__xnor2_1
XFILLER_5_273 VPWR VGND VPWR VGND sky130_fd_sc_hd__decap_6
X_2450_ VGND VPWR VPWR VGND _2592_/CLK _2450_/D fanout148/X _2450_/Q sky130_fd_sc_hd__dfrtp_1
X_1194_ VPWR VGND VGND VPWR _2255_/A _1512_/A sky130_fd_sc_hd__inv_1
X_1332_ VPWR VGND VGND VPWR _2481_/Q _1332_/B _1332_/Y sky130_fd_sc_hd__nor2_1
X_1263_ VPWR VGND VGND VPWR _2412_/Q _1265_/C _2413_/Q sky130_fd_sc_hd__nand2_1
XFILLER_51_169 VGND VPWR VPWR VGND sky130_fd_sc_hd__decap_12
X_2579_ VGND VPWR VPWR VGND _2634_/CLK _2579_/D load_slew177/X _2579_/Q sky130_fd_sc_hd__dfrtp_1
XFILLER_19_46 VPWR VGND VPWR VGND sky130_fd_sc_hd__decap_8
XFILLER_35_45 VPWR VGND VPWR VGND sky130_fd_sc_hd__decap_3
XFILLER_19_57 VGND VPWR VPWR VGND sky130_fd_sc_hd__decap_12
XFILLER_2_276 VGND VPWR VPWR VGND sky130_fd_sc_hd__decap_12
X_1950_ VPWR VGND VGND VPWR _2549_/Q _1950_/Y _2575_/Q _1956_/S sky130_fd_sc_hd__mux2i_1
X_2502_ VGND VPWR VPWR VGND _2634_/CLK _2502_/D load_slew175/X _2502_/Q sky130_fd_sc_hd__dfrtp_1
X_1881_ VPWR VGND VGND VPWR _2526_/Q _1881_/Y _2600_/Q _1884_/S sky130_fd_sc_hd__mux2i_1
XFILLER_51_3 VGND VPWR VPWR VGND sky130_fd_sc_hd__decap_4
X_1315_ VPWR VGND VGND VPWR _1340_/A _1315_/Y _1315_/B sky130_fd_sc_hd__nand2_1
X_2433_ VPWR VGND VPWR VGND _2433_/Q fanout159/X _2433_/D clkload4/A sky130_fd_sc_hd__dfstp_2
X_2364_ VGND VPWR VPWR VGND _2364_/Y _2362_/Y _1557_/A _2330_/B _2297_/A _2363_/Y
+ sky130_fd_sc_hd__a221oi_1
XPHY_EDGE_ROW_22_Left_93 VPWR VGND VPWR VGND sky130_fd_sc_hd__decap_3
X_1246_ VPWR VGND VGND VPWR _2465_/Q _1246_/Y sky130_fd_sc_hd__inv_1
X_2295_ VPWR VGND VGND VPWR _2295_/A _2295_/B _2296_/B sky130_fd_sc_hd__nor2_1
XFILLER_32_191 VGND VPWR VPWR VGND sky130_fd_sc_hd__decap_4
XFILLER_21_47 VPWR VGND VPWR VGND sky130_fd_sc_hd__decap_8
XFILLER_47_217 VPWR VGND VPWR VGND sky130_fd_sc_hd__decap_6
XFILLER_70_253 VGND VPWR VPWR VGND sky130_fd_sc_hd__decap_4
Xmax_cap56 VGND VPWR fanout49/A _1834_/Y VPWR VGND sky130_fd_sc_hd__buf_1
Xmax_cap34 VGND VPWR VPWR VGND _2249_/Y _2264_/B sky130_fd_sc_hd__clkdlybuf4s25_1
XFILLER_23_191 VGND VPWR VPWR VGND sky130_fd_sc_hd__decap_12
XFILLER_46_261 VPWR VGND VPWR VGND sky130_fd_sc_hd__decap_3
X_2080_ VPWR VGND VPWR VGND _2082_/A _2080_/C _2080_/D _2080_/Y _2080_/B sky130_fd_sc_hd__nand4_1
X_1933_ VPWR VGND VGND VPWR _1933_/A _1933_/Y _1933_/B sky130_fd_sc_hd__nand2_1
X_1795_ VPWR VGND VPWR VGND _2634_/Q _2495_/Q hold347/X _1795_/Y sky130_fd_sc_hd__a21oi_1
X_1864_ VPWR VGND VGND VPWR _1864_/A _1864_/Y _1933_/B sky130_fd_sc_hd__nand2_1
X_2278_ VGND VPWR VPWR VGND _2295_/A _2279_/B _2279_/A sky130_fd_sc_hd__and2_0
X_2347_ VPWR VGND VPWR VGND _2346_/C _2346_/B _2351_/A _2348_/B sky130_fd_sc_hd__a21o_1
X_2416_ VGND VPWR VPWR VGND clkload4/A _2416_/D _2437_/SET_B _2416_/Q sky130_fd_sc_hd__dfrtp_1
XFILLER_52_253 VPWR VGND VPWR VGND sky130_fd_sc_hd__decap_6
X_1229_ VPWR VGND VGND VPWR _2455_/Q _1229_/Y sky130_fd_sc_hd__inv_1
XFILLER_20_150 VPWR VGND VPWR VGND sky130_fd_sc_hd__decap_8
X_1580_ VPWR VGND VGND VPWR _1580_/C _1584_/C _1977_/B _2623_/D sky130_fd_sc_hd__nor3_1
XFILLER_11_161 VPWR VGND VPWR VGND sky130_fd_sc_hd__decap_6
X_2201_ VPWR VGND VGND VPWR _2203_/B _2201_/C _2201_/A _2201_/B sky130_fd_sc_hd__maj3_1
X_2132_ VPWR VGND VPWR VGND _1657_/D _2077_/B locked _2132_/Y sky130_fd_sc_hd__a21oi_1
XFILLER_34_253 VGND VPWR VPWR VGND sky130_fd_sc_hd__decap_12
X_2063_ VGND VPWR VPWR VGND _2395_/D hold369/X _2067_/S _2453_/Q sky130_fd_sc_hd__mux2_1
X_1847_ VGND VPWR VGND VPWR _1846_/Y _1945_/B _2515_/D _1845_/Y sky130_fd_sc_hd__o21ai_0
X_1916_ VGND VPWR VGND VPWR _1915_/Y _1948_/B _2538_/D _1914_/Y sky130_fd_sc_hd__o21ai_0
X_1778_ VPWR VGND VGND VPWR _1778_/A _1999_/S _1778_/Y sky130_fd_sc_hd__nor2_1
XPHY_EDGE_ROW_31_Left_102 VPWR VGND VPWR VGND sky130_fd_sc_hd__decap_3
XPHY_EDGE_ROW_40_Left_111 VPWR VGND VPWR VGND sky130_fd_sc_hd__decap_3
XFILLER_17_209 VPWR VGND VPWR VGND sky130_fd_sc_hd__decap_3
XFILLER_4_102 VGND VPWR VPWR VGND sky130_fd_sc_hd__decap_4
XFILLER_67_109 VPWR VGND VPWR VGND sky130_fd_sc_hd__decap_3
XFILLER_4_168 VPWR VGND VPWR VGND sky130_fd_sc_hd__decap_8
XFILLER_16_253 VGND VPWR VPWR VGND sky130_fd_sc_hd__decap_4
XFILLER_31_256 VPWR VGND VPWR VGND sky130_fd_sc_hd__decap_3
X_1701_ VPWR VGND VPWR VGND _1700_/Y _1672_/C _2327_/B _2483_/D sky130_fd_sc_hd__a21oi_1
X_1494_ VPWR VGND VPWR VGND _2617_/Q _2618_/Q _2619_/Q _1570_/B sky130_fd_sc_hd__a21oi_1
X_1632_ VPWR VGND VGND VPWR _1225_/Y _2459_/D _1631_/Y _1638_/S sky130_fd_sc_hd__mux2i_1
X_1563_ VPWR VGND VGND VPWR _1563_/A _1563_/B _2610_/D _1563_/C sky130_fd_sc_hd__nand3_1
X_2115_ VPWR VGND _2114_/B _2114_/C wire16/X _2115_/Y _2419_/Q VPWR VGND sky130_fd_sc_hd__o31ai_1
X_2046_ VPWR VGND VGND VPWR _2046_/A _2050_/B _2046_/Y sky130_fd_sc_hd__nor2_1
Xfanout38 VGND VPWR VGND VPWR _1474_/Y _1523_/A sky130_fd_sc_hd__clkdlybuf4s50_1
Xfanout49 VGND VPWR VGND VPWR fanout49/A _1924_/B sky130_fd_sc_hd__clkdlybuf4s50_1
Xfanout27 VGND VPWR VGND VPWR _2164_/Y _2286_/S sky130_fd_sc_hd__clkdlybuf4s50_1
XFILLER_70_76 VPWR VGND VPWR VGND sky130_fd_sc_hd__decap_8
XFILLER_70_65 VGND VPWR VPWR VGND sky130_fd_sc_hd__decap_4
XFILLER_9_249 VGND VPWR VPWR VGND sky130_fd_sc_hd__decap_12
XFILLER_0_193 VPWR VGND VPWR VGND sky130_fd_sc_hd__decap_3
X_1477_ VPWR VGND VGND VPWR _1477_/A _1502_/B _1477_/B sky130_fd_sc_hd__nand2_1
X_2595_ VGND VPWR VPWR VGND clkload6/A _2595_/D load_slew142/X _2595_/Q sky130_fd_sc_hd__dfrtp_1
X_1615_ VPWR VGND VGND VPWR _1627_/A _1615_/Y _2452_/Q sky130_fd_sc_hd__nand2_1
X_1546_ VPWR VGND _2077_/B _2098_/D _1540_/X _2611_/D _1545_/Y VPWR VGND sky130_fd_sc_hd__o31ai_1
XFILLER_54_101 VPWR VGND VPWR VGND sky130_fd_sc_hd__decap_6
X_2029_ VPWR VGND VPWR VGND _2028_/B _1229_/Y _2028_/Y _2596_/D sky130_fd_sc_hd__a21oi_1
Xhold271 hold271/X _2578_/Q VPWR VGND VGND VPWR sky130_fd_sc_hd__dlygate4sd3_1
Xhold260 _2577_/D _1997_/X VPWR VGND VGND VPWR sky130_fd_sc_hd__dlygate4sd3_1
XFILLER_40_57 VGND VPWR VPWR VGND sky130_fd_sc_hd__decap_4
Xhold282 _1975_/A _2558_/Q VPWR VGND VGND VPWR sky130_fd_sc_hd__dlygate4sd3_1
Xhold293 _2022_/A _2593_/Q VPWR VGND VGND VPWR sky130_fd_sc_hd__dlygate4sd3_1
X_2380_ VPWR VGND VGND VPWR _1240_/Y _2444_/D _2379_/Y _2380_/S sky130_fd_sc_hd__mux2i_1
X_1400_ VGND VPWR _2283_/A _1421_/B _1486_/A VPWR VGND sky130_fd_sc_hd__xnor2_1
X_1331_ VGND VPWR _1331_/B _1332_/B _1331_/A VPWR VGND sky130_fd_sc_hd__xnor2_1
X_1193_ VPWR VGND VGND VPWR _2230_/A _2272_/B sky130_fd_sc_hd__inv_1
X_1262_ VPWR VGND VGND VPWR _2410_/Q _2409_/Q _1264_/A _1262_/C sky130_fd_sc_hd__nand3_1
X_2578_ VGND VPWR VPWR VGND _2634_/CLK _2578_/D load_slew177/X _2578_/Q sky130_fd_sc_hd__dfrtp_1
X_1529_ VPWR VGND VPWR VGND _1528_/X _2627_/Q _1524_/Y _1529_/X _2628_/Q sky130_fd_sc_hd__a22o_1
XPHY_EDGE_ROW_14_Right_14 VPWR VGND VPWR VGND sky130_fd_sc_hd__decap_3
XPHY_EDGE_ROW_23_Right_23 VPWR VGND VPWR VGND sky130_fd_sc_hd__decap_3
XFILLER_58_281 VPWR VGND VPWR VGND sky130_fd_sc_hd__decap_8
XPHY_EDGE_ROW_32_Right_32 VPWR VGND VPWR VGND sky130_fd_sc_hd__decap_3
X_1880_ VGND VPWR VGND VPWR _1879_/Y _1951_/B _1880_/Y _1878_/Y sky130_fd_sc_hd__o21ai_0
XFILLER_18_189 VPWR VGND VPWR VGND sky130_fd_sc_hd__decap_6
X_2501_ VGND VPWR VPWR VGND _2607_/CLK _2501_/D _2494_/SET_B _2501_/Q sky130_fd_sc_hd__dfrtp_1
XFILLER_44_3 VPWR VGND VPWR VGND sky130_fd_sc_hd__decap_8
XPHY_EDGE_ROW_41_Right_41 VPWR VGND VPWR VGND sky130_fd_sc_hd__decap_3
X_1314_ wire43/A _1298_/Y _1308_/Y _1311_/A _1305_/B _1299_/Y VPWR VGND VGND VPWR
+ sky130_fd_sc_hd__o311ai_1
X_2294_ VPWR VGND VGND VPWR _2294_/A _2294_/B _2296_/A sky130_fd_sc_hd__nor2_1
X_2363_ VPWR VGND VPWR VGND _2331_/B _2316_/B _2297_/A _2363_/Y sky130_fd_sc_hd__a21oi_1
X_2432_ VPWR VGND VPWR VGND _2432_/Q fanout163/X _2432_/D clkload3/A sky130_fd_sc_hd__dfstp_2
X_1245_ VPWR VGND VGND VPWR _2464_/Q _1245_/Y sky130_fd_sc_hd__inv_1
XPHY_EDGE_ROW_50_Right_50 VPWR VGND VPWR VGND sky130_fd_sc_hd__decap_3
XFILLER_32_181 VPWR VGND VPWR VGND sky130_fd_sc_hd__decap_3
Xmax_cap35 VGND VPWR _1523_/B _1482_/Y VPWR VGND sky130_fd_sc_hd__buf_1
Xmax_cap24 VGND VPWR _1455_/B _2098_/D VPWR VGND sky130_fd_sc_hd__clkbuf_2
Xmax_cap57 VGND VPWR VPWR VGND _2080_/C _2083_/B1 sky130_fd_sc_hd__clkdlybuf4s25_1
XFILLER_15_148 VGND VPWR VPWR VGND sky130_fd_sc_hd__decap_12
X_1932_ VPWR VGND VGND VPWR _2543_/Q _1932_/Y _2569_/Q _1932_/S sky130_fd_sc_hd__mux2i_1
X_1863_ VPWR VGND VGND VPWR _2520_/Q _1863_/Y _2594_/Q _1926_/S sky130_fd_sc_hd__mux2i_1
X_1794_ VGND VPWR _1798_/C _2634_/Q _2495_/Q _2496_/Q VPWR VGND sky130_fd_sc_hd__and3_1
X_2415_ VGND VPWR VPWR VGND clkload4/A _2415_/D _2437_/SET_B _2415_/Q sky130_fd_sc_hd__dfrtp_1
X_2277_ VGND VPWR VGND VPWR _2258_/Y _2257_/A _2279_/B _1512_/A sky130_fd_sc_hd__o21ai_0
X_2346_ VPWR VGND VGND VPWR _2351_/A _2346_/B _2348_/A _2346_/C sky130_fd_sc_hd__nand3_1
X_1228_ VPWR VGND VGND VPWR _2456_/Q _1228_/Y sky130_fd_sc_hd__inv_1
XFILLER_52_232 VPWR VGND VPWR VGND sky130_fd_sc_hd__decap_8
XFILLER_22_80 VGND VPWR VPWR VGND sky130_fd_sc_hd__decap_4
X_2200_ VGND VPWR _2200_/B _2203_/A _2200_/A VPWR VGND sky130_fd_sc_hd__xnor2_1
X_2131_ VGND VPWR VGND VPWR _2130_/Y _1539_/B _2421_/D _2010_/B sky130_fd_sc_hd__o21ai_0
X_2062_ VGND VPWR VPWR VGND _2394_/D hold372/X _2067_/S _2452_/Q sky130_fd_sc_hd__mux2_1
XFILLER_34_265 VPWR VGND VPWR VGND sky130_fd_sc_hd__decap_6
X_1777_ VGND VPWR _1777_/B _1777_/Y _1777_/A VPWR VGND sky130_fd_sc_hd__xnor2_1
X_1846_ VPWR VGND VGND VPWR _1846_/A _1846_/Y _1945_/B sky130_fd_sc_hd__nand2_1
XFILLER_8_93 VGND VPWR VPWR VGND sky130_fd_sc_hd__decap_4
Xclkbuf_leaf_14_clk VGND VPWR VGND VPWR clkbuf_leaf_9_clk/A clkload7/A sky130_fd_sc_hd__clkbuf_16
X_1915_ VPWR VGND VGND VPWR _1915_/A _1915_/Y _1948_/B sky130_fd_sc_hd__nand2_1
XPHY_EDGE_ROW_4_Right_4 VPWR VGND VPWR VGND sky130_fd_sc_hd__decap_3
X_2329_ VPWR VGND VPWR VGND _2359_/S _2289_/A _2328_/Y _2329_/Y sky130_fd_sc_hd__a21oi_1
XFILLER_25_254 VGND VPWR VPWR VGND sky130_fd_sc_hd__decap_4
XFILLER_4_114 VPWR VGND VPWR VGND sky130_fd_sc_hd__decap_8
X_1631_ VPWR VGND VGND VPWR _2383_/A _1631_/Y _2460_/Q sky130_fd_sc_hd__nand2_1
X_1700_ VPWR VGND VGND VPWR _1702_/B _1700_/Y _1700_/B sky130_fd_sc_hd__nand2_1
X_1493_ VGND VPWR _1573_/C _2618_/Q _2619_/Q _2617_/Q VPWR VGND sky130_fd_sc_hd__and3_1
Xclkbuf_leaf_3_clk VGND VPWR VGND VPWR clkload0/A clkload9/A sky130_fd_sc_hd__clkbuf_16
X_1562_ VPWR VGND VPWR VGND _1651_/C _2052_/C _1563_/C _1255_/Y _1559_/Y sky130_fd_sc_hd__a22oi_1
X_2045_ VPWR VGND VPWR VGND _1999_/S _1244_/Y _2044_/Y _2604_/D sky130_fd_sc_hd__a21oi_1
X_2114_ VPWR VGND VPWR VGND _2114_/B wire16/X _2114_/C _2419_/Q _2114_/X sky130_fd_sc_hd__or4_1
Xfanout28 VGND VPWR VGND VPWR _2168_/A _2167_/A sky130_fd_sc_hd__clkdlybuf4s50_1
Xfanout17 VGND VPWR VGND VPWR _1537_/X _1603_/A sky130_fd_sc_hd__clkdlybuf4s50_1
X_1829_ VGND VPWR _1829_/B _2509_/D _1829_/A VPWR VGND sky130_fd_sc_hd__xnor2_1
XFILLER_38_24 VGND VPWR VPWR VGND sky130_fd_sc_hd__decap_4
XFILLER_54_23 VGND VPWR VPWR VGND sky130_fd_sc_hd__decap_4
XFILLER_13_213 VPWR VGND VPWR VGND sky130_fd_sc_hd__decap_6
X_2594_ VGND VPWR VPWR VGND clkload6/A _2594_/D fanout145/X _2594_/Q sky130_fd_sc_hd__dfrtp_1
X_1614_ VPWR VGND VGND VPWR _1234_/Y _2450_/D _1613_/Y _1628_/S sky130_fd_sc_hd__mux2i_1
X_1476_ VPWR VGND VGND VPWR _2171_/A _2187_/B _2185_/B _1496_/A sky130_fd_sc_hd__nor3_1
X_1545_ VPWR VGND VPWR VGND _1541_/Y _2167_/A _1544_/Y _1545_/Y sky130_fd_sc_hd__a21oi_1
X_2028_ VPWR VGND VGND VPWR _2028_/A _2028_/B _2028_/Y sky130_fd_sc_hd__nor2_1
XFILLER_10_227 VPWR VGND VPWR VGND sky130_fd_sc_hd__decap_8
Xhold283 hold283/X _2580_/Q VPWR VGND VGND VPWR sky130_fd_sc_hd__dlygate4sd3_1
Xhold272 _2578_/D _1998_/X VPWR VGND VGND VPWR sky130_fd_sc_hd__dlygate4sd3_1
Xhold250 _2537_/D _1913_/Y VPWR VGND VGND VPWR sky130_fd_sc_hd__dlygate4sd3_1
Xhold261 hold261/X _2564_/Q VPWR VGND VGND VPWR sky130_fd_sc_hd__dlygate4sd3_1
Xhold294 hold294/X _2568_/Q VPWR VGND VGND VPWR sky130_fd_sc_hd__dlygate4sd3_1
XFILLER_68_205 VPWR VGND VPWR VGND sky130_fd_sc_hd__decap_3
X_1330_ VGND VPWR VPWR VGND _1340_/C _1340_/B _1340_/A _1331_/B _1341_/A sky130_fd_sc_hd__a31oi_1
X_1261_ VPWR VGND VGND VPWR _2410_/Q _2082_/B _2409_/Q sky130_fd_sc_hd__nand2_1
X_1192_ VPWR VGND VGND VPWR _2287_/B _1519_/A sky130_fd_sc_hd__inv_1
XFILLER_44_190 VPWR VGND VPWR VGND sky130_fd_sc_hd__decap_6
X_2577_ VGND VPWR VPWR VGND clkload9/A _2577_/D load_slew166/X _2577_/Q sky130_fd_sc_hd__dfrtp_1
X_1459_ VGND VPWR VPWR VGND _2613_/Q _1459_/X _2612_/Q sky130_fd_sc_hd__xor2_1
X_1528_ VPWR VGND VGND VPWR _1486_/Y _1527_/Y _1530_/A _1528_/X sky130_fd_sc_hd__o21a_1
XFILLER_42_105 VPWR VGND VPWR VGND sky130_fd_sc_hd__decap_6
X_2500_ VGND VPWR VPWR VGND _2634_/CLK _2500_/D _2494_/SET_B _2500_/Q sky130_fd_sc_hd__dfrtp_1
X_2431_ VPWR VGND VPWR VGND _2431_/Q fanout185/X _2431_/D _2616_/CLK sky130_fd_sc_hd__dfstp_2
X_1244_ VPWR VGND VGND VPWR _2463_/Q _1244_/Y sky130_fd_sc_hd__inv_1
X_1313_ VGND VPWR VPWR VGND _2287_/B _1340_/A _2230_/A sky130_fd_sc_hd__xor2_1
X_2362_ VGND VPWR VGND VPWR _1364_/B _1413_/C _2362_/Y _2355_/Y sky130_fd_sc_hd__o21ai_0
X_2293_ VPWR VGND VGND VPWR _2293_/A _2294_/B sky130_fd_sc_hd__inv_1
X_2629_ VGND VPWR VPWR VGND clkload3/A _2629_/D fanout161/X _2629_/Q sky130_fd_sc_hd__dfrtp_1
Xmax_cap58 VGND VPWR VPWR VGND _2375_/C _2080_/C sky130_fd_sc_hd__clkdlybuf4s25_1
XFILLER_61_266 VGND VPWR VPWR VGND sky130_fd_sc_hd__decap_12
X_1793_ VGND VPWR VPWR VGND _1793_/A _1793_/X _2634_/Q sky130_fd_sc_hd__xor2_1
X_1862_ VGND VPWR VGND VPWR _1861_/Y _1933_/B _2520_/D _1860_/Y sky130_fd_sc_hd__o21ai_0
X_1931_ VGND VPWR VGND VPWR _1930_/Y _1930_/B _2543_/D _1929_/Y sky130_fd_sc_hd__o21ai_0
X_2414_ VGND VPWR VPWR VGND clkload4/A _2414_/D _2437_/SET_B _2414_/Q sky130_fd_sc_hd__dfrtp_1
X_2276_ VPWR VGND VGND VPWR _2276_/A _2290_/B _2279_/A sky130_fd_sc_hd__nor2_1
X_2345_ VPWR VGND VPWR VGND _2345_/Y _2360_/A _2344_/Y _2307_/A _2359_/S sky130_fd_sc_hd__a211oi_1
X_1227_ VPWR VGND VGND VPWR _2457_/Q _1227_/Y sky130_fd_sc_hd__inv_1
XFILLER_52_277 VGND VPWR VPWR VGND sky130_fd_sc_hd__decap_12
X_2130_ VPWR VGND VPWR VGND _2130_/A _2130_/C _2130_/D _2130_/Y _2130_/B sky130_fd_sc_hd__nand4_1
XFILLER_34_200 VGND VPWR VPWR VGND sky130_fd_sc_hd__decap_12
X_2061_ VGND VPWR VPWR VGND _2393_/D _2393_/Q _2067_/S _2451_/Q sky130_fd_sc_hd__mux2_1
X_1914_ VPWR VGND VGND VPWR _2537_/Q _1914_/Y _2563_/Q _1917_/S sky130_fd_sc_hd__mux2i_1
X_1776_ VGND VPWR _2406_/Q _1777_/B _2464_/Q VPWR VGND sky130_fd_sc_hd__xnor2_1
X_1845_ VPWR VGND VGND VPWR _2514_/Q _1845_/Y hold378/X _1884_/S sky130_fd_sc_hd__mux2i_1
X_2328_ VPWR VGND VGND VPWR _2331_/A _2359_/S _2328_/Y sky130_fd_sc_hd__nor2_1
X_2259_ VGND VPWR _2259_/B _2260_/C _2259_/A VPWR VGND sky130_fd_sc_hd__xnor2_1
XFILLER_31_236 VGND VPWR VPWR VGND sky130_fd_sc_hd__decap_12
XFILLER_31_225 VGND VPWR VPWR VGND sky130_fd_sc_hd__decap_4
XFILLER_17_92 VGND VPWR VPWR VGND sky130_fd_sc_hd__decap_12
X_1630_ VPWR VGND VGND VPWR _1226_/Y _2458_/D _1629_/Y _2380_/S sky130_fd_sc_hd__mux2i_1
X_1492_ VGND VPWR VGND VPWR _1504_/B _2137_/A _1477_/B _1469_/Y locked sky130_fd_sc_hd__o211a_1
X_1561_ VPWR VGND VGND VPWR _1651_/B _1561_/B _2052_/C sky130_fd_sc_hd__nor2_1
X_2044_ VPWR VGND VGND VPWR _2044_/A _2050_/B _2044_/Y sky130_fd_sc_hd__nor2_1
X_2113_ VGND VPWR VGND VPWR _2101_/Y _2111_/Y _2112_/Y _2418_/D sky130_fd_sc_hd__o21ba_1
Xfanout18 VGND VPWR VGND VPWR _1537_/X _1977_/B sky130_fd_sc_hd__clkdlybuf4s50_1
X_1828_ VGND VPWR VPWR VGND _1828_/A _2508_/D _1828_/B sky130_fd_sc_hd__xor2_1
X_1759_ VPWR VGND VPWR VGND _1757_/B _1752_/X _1754_/B _1763_/A sky130_fd_sc_hd__a21oi_1
XFILLER_1_107 VGND VPWR VPWR VGND sky130_fd_sc_hd__decap_4
XFILLER_57_177 VGND VPWR VPWR VGND sky130_fd_sc_hd__decap_12
XFILLER_57_199 VPWR VGND VPWR VGND sky130_fd_sc_hd__decap_3
XFILLER_13_258 VPWR VGND VPWR VGND sky130_fd_sc_hd__decap_3
XFILLER_70_23 VGND VPWR VPWR VGND sky130_fd_sc_hd__decap_4
XFILLER_63_169 VGND VPWR VPWR VGND sky130_fd_sc_hd__decap_4
XFILLER_48_144 VGND VPWR VPWR VGND sky130_fd_sc_hd__decap_4
XFILLER_67_3 VPWR VGND VPWR VGND sky130_fd_sc_hd__decap_8
X_2593_ VGND VPWR VPWR VGND clkload6/A _2593_/D fanout145/X _2593_/Q sky130_fd_sc_hd__dfrtp_1
X_1544_ VGND VPWR VGND VPWR _1543_/Y _2101_/A _1544_/Y _2096_/A sky130_fd_sc_hd__o21ai_0
X_1613_ VPWR VGND VGND VPWR _1627_/A _1613_/Y _2451_/Q sky130_fd_sc_hd__nand2_1
X_1475_ VPWR VGND VGND VPWR _2158_/B _1488_/A _1484_/B sky130_fd_sc_hd__nand2_1
XFILLER_39_188 VPWR VGND VPWR VGND sky130_fd_sc_hd__decap_6
X_2027_ VPWR VGND VPWR VGND _2028_/B _1230_/Y _2026_/Y _2595_/D sky130_fd_sc_hd__a21oi_1
XFILLER_40_15 VGND VPWR VPWR VGND sky130_fd_sc_hd__decap_12
Xhold262 _1969_/A _2556_/Q VPWR VGND VGND VPWR sky130_fd_sc_hd__dlygate4sd3_1
Xhold284 _2580_/D _2000_/X VPWR VGND VGND VPWR sky130_fd_sc_hd__dlygate4sd3_1
Xhold240 _2552_/D _1958_/Y VPWR VGND VGND VPWR sky130_fd_sc_hd__dlygate4sd3_1
Xhold251 hold251/X _2511_/Q VPWR VGND VGND VPWR sky130_fd_sc_hd__dlygate4sd3_1
Xhold273 hold273/X _2569_/Q VPWR VGND VGND VPWR sky130_fd_sc_hd__dlygate4sd3_1
Xhold295 _2018_/A _2591_/Q VPWR VGND VGND VPWR sky130_fd_sc_hd__dlygate4sd3_1
XFILLER_45_158 VPWR VGND VPWR VGND sky130_fd_sc_hd__decap_8
X_1260_ VPWR VGND VGND VPWR i2s_sd _1260_/Y sky130_fd_sc_hd__inv_1
X_2576_ VGND VPWR VPWR VGND clkload9/A _2576_/D load_slew168/X _2576_/Q sky130_fd_sc_hd__dfrtp_1
X_1527_ VPWR VGND VGND VPWR _2272_/A _1527_/Y locked sky130_fd_sc_hd__nand2_1
XFILLER_10_29 VGND VPWR VPWR VGND sky130_fd_sc_hd__decap_4
X_1458_ VGND VPWR _2612_/Q _1458_/Y _2613_/Q VPWR VGND sky130_fd_sc_hd__xnor2_1
X_1389_ VPWR VGND VGND VPWR _1428_/A _1429_/B _2213_/B _1389_/B sky130_fd_sc_hd__maj3_1
X_2430_ VPWR VGND VPWR VGND _2430_/Q fanout185/X _2430_/D clkload3/A sky130_fd_sc_hd__dfstp_2
X_2361_ VPWR VGND VPWR VGND _2437_/D fanout3/X _2358_/Y _2360_/Y _2316_/B _2096_/A
+ sky130_fd_sc_hd__o32a_1
XFILLER_56_209 VPWR VGND VPWR VGND sky130_fd_sc_hd__decap_6
X_1243_ VPWR VGND VGND VPWR _2462_/Q _1243_/Y sky130_fd_sc_hd__inv_1
X_1312_ VGND VPWR VPWR VGND _1312_/Y _1311_/X _1307_/Y _2477_/Q _1305_/Y _2478_/Q
+ sky130_fd_sc_hd__a221oi_1
X_2292_ VGND VPWR VGND VPWR _2290_/C _2290_/A _2293_/A _2290_/B sky130_fd_sc_hd__o21ai_0
XFILLER_32_161 VGND VPWR VPWR VGND sky130_fd_sc_hd__decap_12
X_2559_ VGND VPWR VPWR VGND _2633_/CLK _2559_/D fanout187/X i2s_bclk sky130_fd_sc_hd__dfrtp_1
X_2628_ VGND VPWR VPWR VGND clkload3/A _2628_/D _2429_/SET_B _2628_/Q sky130_fd_sc_hd__dfrtp_1
XFILLER_55_275 VGND VPWR VPWR VGND sky130_fd_sc_hd__decap_4
XFILLER_55_220 VGND VPWR VPWR VGND sky130_fd_sc_hd__decap_4
Xmax_cap15 VGND VPWR wire16/X _2102_/D VPWR VGND sky130_fd_sc_hd__clkbuf_2
XFILLER_46_253 VPWR VGND VPWR VGND sky130_fd_sc_hd__decap_8
X_1930_ VPWR VGND VGND VPWR _1930_/A _1930_/Y _1930_/B sky130_fd_sc_hd__nand2_1
X_1792_ VGND VPWR VGND VPWR _1791_/Y _1259_/Y _2494_/D _2003_/S sky130_fd_sc_hd__o21ai_0
X_1861_ VPWR VGND VGND VPWR _1861_/A _1861_/Y _1933_/B sky130_fd_sc_hd__nand2_1
XPHY_EDGE_ROW_26_Left_97 VPWR VGND VPWR VGND sky130_fd_sc_hd__decap_3
X_2413_ VGND VPWR VPWR VGND _2592_/CLK _2413_/D load_slew147/X _2413_/Q sky130_fd_sc_hd__dfrtp_1
X_2344_ VPWR VGND VGND VPWR _2351_/A _2359_/S _2344_/Y sky130_fd_sc_hd__nor2_1
Xclkbuf_1_0__f_clk VGND VPWR VGND VPWR clkbuf_0_clk/X clkbuf_leaf_9_clk/A sky130_fd_sc_hd__clkbuf_16
XFILLER_52_223 VGND VPWR VPWR VGND sky130_fd_sc_hd__decap_4
XFILLER_52_201 VPWR VGND VPWR VGND sky130_fd_sc_hd__decap_8
X_1226_ VPWR VGND VGND VPWR _2458_/Q _1226_/Y sky130_fd_sc_hd__inv_1
X_2275_ VGND VPWR VPWR VGND _2290_/B _2275_/B _2482_/Q sky130_fd_sc_hd__and2_0
XFILLER_52_267 VPWR VGND VPWR VGND sky130_fd_sc_hd__decap_6
XFILLER_57_46 VPWR VGND VPWR VGND sky130_fd_sc_hd__decap_8
XFILLER_7_146 VGND VPWR VPWR VGND sky130_fd_sc_hd__decap_12
X_2060_ VGND VPWR VPWR VGND _2392_/D _2392_/Q _2060_/S _2450_/Q sky130_fd_sc_hd__mux2_1
XFILLER_19_220 VGND VPWR VPWR VGND sky130_fd_sc_hd__decap_4
XFILLER_34_245 VPWR VGND VPWR VGND sky130_fd_sc_hd__decap_6
X_1913_ VGND VPWR VGND VPWR _1912_/Y _1948_/B _1913_/Y _1911_/Y sky130_fd_sc_hd__o21ai_0
X_1775_ VPWR VGND VGND VPWR _2464_/Q _2406_/Q _2119_/D sky130_fd_sc_hd__nor2_1
X_1844_ VGND VPWR VGND VPWR _1843_/Y _1954_/B _1844_/Y _1842_/Y sky130_fd_sc_hd__o21ai_0
X_2258_ VPWR VGND VGND VPWR _2481_/Q _2258_/Y _2259_/B sky130_fd_sc_hd__nand2_1
X_2327_ VPWR VGND VGND VPWR _2331_/A _2327_/B _2327_/Y sky130_fd_sc_hd__nor2_1
X_2189_ VPWR VGND VGND VPWR _2189_/A _2189_/Y _2189_/B sky130_fd_sc_hd__nand2_1
X_1209_ VPWR VGND VGND VPWR _2480_/Q _1692_/A sky130_fd_sc_hd__inv_1
XFILLER_27_49 VGND VPWR VPWR VGND sky130_fd_sc_hd__decap_4
XFILLER_31_248 VPWR VGND VPWR VGND sky130_fd_sc_hd__decap_8
XFILLER_16_245 VPWR VGND VPWR VGND sky130_fd_sc_hd__decap_6
XFILLER_17_82 VPWR VGND VPWR VGND sky130_fd_sc_hd__decap_6
X_1560_ VPWR VGND VGND VPWR _2096_/A _1560_/B _1560_/Y _2168_/B sky130_fd_sc_hd__nand3_1
X_1491_ VGND VPWR _1507_/A _1491_/Y _2198_/A VPWR VGND sky130_fd_sc_hd__xnor2_1
X_2112_ VGND VPWR VPWR VGND _2108_/C _2108_/B _1550_/B _2112_/Y _1550_/A sky130_fd_sc_hd__a31oi_1
X_2043_ VPWR VGND VPWR VGND _2042_/B _1243_/Y _2042_/Y _2603_/D sky130_fd_sc_hd__a21oi_1
X_1827_ VPWR VGND VGND VPWR _1828_/B _1827_/B _2507_/D sky130_fd_sc_hd__nor2_1
X_1758_ VGND VPWR VPWR VGND _2488_/D _1757_/Y _1999_/S hold318/X sky130_fd_sc_hd__mux2_1
X_1689_ VPWR VGND VPWR VGND _1688_/Y _1671_/Y _2136_/A _2478_/D sky130_fd_sc_hd__a21oi_1
XFILLER_57_189 VGND VPWR VPWR VGND sky130_fd_sc_hd__decap_4
XPHY_EDGE_ROW_13_Left_84 VPWR VGND VPWR VGND sky130_fd_sc_hd__decap_3
XFILLER_70_57 VGND VPWR VPWR VGND sky130_fd_sc_hd__decap_4
XFILLER_21_281 VPWR VGND VPWR VGND sky130_fd_sc_hd__decap_8
XFILLER_48_156 VPWR VGND VPWR VGND sky130_fd_sc_hd__decap_3
XFILLER_8_230 VGND VPWR VPWR VGND sky130_fd_sc_hd__decap_12
X_1474_ VPWR VGND _1302_/Y _1339_/B _1472_/Y _1474_/Y locked VPWR VGND sky130_fd_sc_hd__o31ai_1
X_2592_ VGND VPWR VPWR VGND _2592_/CLK _2592_/D load_slew147/X _2592_/Q sky130_fd_sc_hd__dfrtp_1
X_1543_ VPWR VGND VGND VPWR _1543_/Y _2609_/Q _1543_/B _2440_/Q _2439_/Q sky130_fd_sc_hd__nand4b_1
X_1612_ VPWR VGND VGND VPWR _1235_/Y _2449_/D _1611_/Y _1628_/S sky130_fd_sc_hd__mux2i_1
XFILLER_62_170 VGND VPWR VPWR VGND sky130_fd_sc_hd__decap_12
X_2026_ VPWR VGND VGND VPWR _2026_/A _2028_/B _2026_/Y sky130_fd_sc_hd__nor2_1
Xhold263 _2556_/D _1970_/Y VPWR VGND VGND VPWR sky130_fd_sc_hd__dlygate4sd3_1
Xhold252 _2511_/D _1835_/X VPWR VGND VGND VPWR sky130_fd_sc_hd__dlygate4sd3_1
Xhold230 _1894_/A _2531_/Q VPWR VGND VGND VPWR sky130_fd_sc_hd__dlygate4sd3_1
Xhold285 _2038_/A _2601_/Q VPWR VGND VGND VPWR sky130_fd_sc_hd__dlygate4sd3_1
Xhold296 _2020_/A _2592_/Q VPWR VGND VGND VPWR sky130_fd_sc_hd__dlygate4sd3_1
Xhold241 _1930_/A _2543_/Q VPWR VGND VGND VPWR sky130_fd_sc_hd__dlygate4sd3_1
Xhold274 _2569_/D _1989_/X VPWR VGND VGND VPWR sky130_fd_sc_hd__dlygate4sd3_1
XFILLER_60_107 VGND VPWR VPWR VGND sky130_fd_sc_hd__decap_4
XFILLER_53_181 VGND VPWR VPWR VGND sky130_fd_sc_hd__decap_12
X_1526_ VGND VPWR VPWR VGND _1522_/Y _1521_/Y _1518_/Y _1526_/Y _1525_/Y sky130_fd_sc_hd__a31oi_1
X_2575_ VGND VPWR VPWR VGND clkload1/A _2575_/D load_slew152/X _2575_/Q sky130_fd_sc_hd__dfrtp_1
X_1457_ VGND VPWR VGND VPWR _2442_/Q wire29/X _1373_/X _2098_/D _1651_/C _1375_/Y
+ sky130_fd_sc_hd__o41ai_2
X_1388_ VGND VPWR VGND VPWR _1386_/Y _1430_/A _1429_/B _1430_/B sky130_fd_sc_hd__o21ai_0
XFILLER_51_15 VGND VPWR VPWR VGND sky130_fd_sc_hd__decap_4
X_2009_ VPWR VGND VPWR VGND _2042_/B _1239_/Y _2008_/Y _2586_/D sky130_fd_sc_hd__a21oi_1
XPHY_EDGE_ROW_38_Left_109 VPWR VGND VPWR VGND sky130_fd_sc_hd__decap_3
XFILLER_33_107 VGND VPWR VPWR VGND sky130_fd_sc_hd__decap_4
XPHY_EDGE_ROW_47_Left_118 VPWR VGND VPWR VGND sky130_fd_sc_hd__decap_3
X_1311_ VGND VPWR VPWR VGND _1311_/A _1311_/X _1311_/B sky130_fd_sc_hd__xor2_1
X_2360_ VPWR VGND VGND VPWR _2360_/A _2360_/B _2360_/Y sky130_fd_sc_hd__nor2_1
X_2291_ VPWR VGND VGND VPWR _2294_/A _2291_/Y sky130_fd_sc_hd__inv_1
XPHY_EDGE_ROW_56_Left_127 VPWR VGND VPWR VGND sky130_fd_sc_hd__decap_3
X_1242_ VPWR VGND VGND VPWR _2461_/Q _1242_/Y sky130_fd_sc_hd__inv_1
XPHY_EDGE_ROW_10_Right_10 VPWR VGND VPWR VGND sky130_fd_sc_hd__decap_3
XFILLER_32_173 VPWR VGND VPWR VGND sky130_fd_sc_hd__decap_8
XPHY_EDGE_ROW_65_Left_136 VPWR VGND VPWR VGND sky130_fd_sc_hd__decap_3
X_2627_ VGND VPWR VPWR VGND clkload3/A _2627_/D _2429_/SET_B _2627_/Q sky130_fd_sc_hd__dfrtp_1
X_2558_ VGND VPWR VPWR VGND _2607_/CLK _2558_/D _2494_/SET_B _2558_/Q sky130_fd_sc_hd__dfrtp_1
X_2489_ VGND VPWR VPWR VGND _2634_/CLK _2489_/D load_slew175/X _2489_/Q sky130_fd_sc_hd__dfrtp_1
X_1509_ VGND VPWR VGND VPWR _2622_/Q _1523_/A _1509_/Y _1507_/Y sky130_fd_sc_hd__o21ai_0
XPHY_EDGE_ROW_1_Left_72 VPWR VGND VPWR VGND sky130_fd_sc_hd__decap_3
X_1860_ VPWR VGND VGND VPWR _2519_/Q _1860_/Y _2593_/Q _1926_/S sky130_fd_sc_hd__mux2i_1
X_1791_ VPWR VGND VGND VPWR _1789_/A _1791_/Y _1786_/Y _2003_/S _1789_/B sky130_fd_sc_hd__o211ai_1
X_2274_ VPWR VGND VGND VPWR _2274_/A _2275_/B _2276_/A sky130_fd_sc_hd__nor2_1
X_2412_ VGND VPWR VPWR VGND _2592_/CLK _2412_/D fanout146/X _2412_/Q sky130_fd_sc_hd__dfrtp_1
X_2343_ VGND VPWR VPWR VGND _2342_/Y _2341_/Y _2136_/B _2435_/D _2327_/Y sky130_fd_sc_hd__a31oi_1
X_1225_ VPWR VGND VGND VPWR _2459_/Q _1225_/Y sky130_fd_sc_hd__inv_1
X_1989_ VGND VPWR VPWR VGND _1989_/X _2394_/Q _2028_/B hold273/X sky130_fd_sc_hd__mux2_1
XFILLER_7_169 VGND VPWR VPWR VGND sky130_fd_sc_hd__decap_12
XFILLER_11_143 VGND VPWR VPWR VGND sky130_fd_sc_hd__decap_12
XFILLER_19_276 VGND VPWR VPWR VGND sky130_fd_sc_hd__decap_4
X_1843_ VPWR VGND VGND VPWR _1843_/A _1843_/Y _1951_/B sky130_fd_sc_hd__nand2_1
X_1912_ VPWR VGND VGND VPWR _1912_/A _1912_/Y _1948_/B sky130_fd_sc_hd__nand2_1
X_1774_ VPWR VGND VGND VPWR _2464_/Q _1774_/Y _2406_/Q sky130_fd_sc_hd__nand2_1
Xclkbuf_leaf_6_clk VGND VPWR VGND VPWR clkload0/A _2606_/CLK sky130_fd_sc_hd__clkbuf_16
XFILLER_6_191 VGND VPWR VPWR VGND sky130_fd_sc_hd__decap_4
X_2257_ VGND VPWR _2257_/B _2259_/B _2257_/A VPWR VGND sky130_fd_sc_hd__xnor2_1
X_2326_ VPWR VGND VPWR VGND _2434_/D fanout3/X _2315_/Y _2325_/Y _2316_/A _2327_/B
+ sky130_fd_sc_hd__o32a_1
X_1208_ VPWR VGND VGND VPWR _2481_/Q _2259_/A sky130_fd_sc_hd__inv_1
X_2188_ VPWR VGND VGND VPWR _2189_/A _2189_/B _2190_/A sky130_fd_sc_hd__nor2_1
XFILLER_25_202 VPWR VGND VPWR VGND sky130_fd_sc_hd__decap_8
X_1490_ VGND VPWR VPWR VGND _1490_/X _1490_/B _1490_/A sky130_fd_sc_hd__and2_0
X_2042_ VPWR VGND VGND VPWR _2042_/A _2042_/B _2042_/Y sky130_fd_sc_hd__nor2_1
X_2111_ VPWR VGND VGND VPWR wire16/X _2114_/C _2114_/B _2111_/Y sky130_fd_sc_hd__nor3_1
XPHY_EDGE_ROW_8_Right_8 VPWR VGND VPWR VGND sky130_fd_sc_hd__decap_3
X_1826_ VPWR VGND VPWR VGND _2633_/Q hold374/X hold340/X _1827_/B sky130_fd_sc_hd__a21oi_1
X_1757_ VGND VPWR _1757_/B _1757_/Y _1757_/A VPWR VGND sky130_fd_sc_hd__xnor2_1
X_1688_ VGND VPWR _1688_/B _1688_/Y _1688_/A VPWR VGND sky130_fd_sc_hd__xnor2_1
XPHY_EDGE_ROW_39_Right_39 VPWR VGND VPWR VGND sky130_fd_sc_hd__decap_3
X_2309_ VGND VPWR VPWR VGND _2322_/A _2311_/A _2322_/B sky130_fd_sc_hd__xor2_1
XPHY_EDGE_ROW_48_Right_48 VPWR VGND VPWR VGND sky130_fd_sc_hd__decap_3
XPHY_EDGE_ROW_57_Right_57 VPWR VGND VPWR VGND sky130_fd_sc_hd__decap_3
XFILLER_0_197 VGND VPWR VPWR VGND sky130_fd_sc_hd__decap_12
XPHY_EDGE_ROW_66_Right_66 VPWR VGND VPWR VGND sky130_fd_sc_hd__decap_3
XFILLER_8_242 VPWR VGND VPWR VGND sky130_fd_sc_hd__decap_8
XFILLER_8_253 VPWR VGND VPWR VGND sky130_fd_sc_hd__decap_8
XFILLER_8_286 VPWR VGND VPWR VGND sky130_fd_sc_hd__decap_3
X_1611_ VPWR VGND VGND VPWR _1627_/A _1611_/Y _2450_/Q sky130_fd_sc_hd__nand2_1
X_1473_ _1484_/B _1302_/Y _1339_/B _1472_/Y locked VPWR VGND VGND VPWR sky130_fd_sc_hd__o31a_1
X_2591_ VGND VPWR VPWR VGND clkload2/A _2591_/D load_slew154/X _2591_/Q sky130_fd_sc_hd__dfrtp_1
X_1542_ VPWR VGND VGND VPWR _1542_/Y _1543_/B _2440_/Q _2439_/Q sky130_fd_sc_hd__nand3b_1
X_2025_ VPWR VGND VPWR VGND _2028_/B _1231_/Y _2024_/Y _2594_/D sky130_fd_sc_hd__a21oi_1
XFILLER_62_182 VPWR VGND VPWR VGND sky130_fd_sc_hd__decap_8
XFILLER_24_29 VGND VPWR VPWR VGND sky130_fd_sc_hd__decap_12
X_1809_ VPWR VGND VGND VPWR _1810_/C _1809_/C _1809_/A _2488_/Q sky130_fd_sc_hd__maj3_1
Xhold242 _1888_/A _2529_/Q VPWR VGND VGND VPWR sky130_fd_sc_hd__dlygate4sd3_1
Xhold253 _1906_/A _2535_/Q VPWR VGND VGND VPWR sky130_fd_sc_hd__dlygate4sd3_1
Xhold231 _1464_/B _2467_/Q VPWR VGND VGND VPWR sky130_fd_sc_hd__dlygate4sd3_1
Xhold220 _1873_/A _2524_/Q VPWR VGND VGND VPWR sky130_fd_sc_hd__dlygate4sd3_1
Xhold286 _2042_/A _2603_/Q VPWR VGND VGND VPWR sky130_fd_sc_hd__dlygate4sd3_1
Xhold264 _1843_/A _2514_/Q VPWR VGND VGND VPWR sky130_fd_sc_hd__dlygate4sd3_1
Xhold297 hold297/X _2563_/Q VPWR VGND VGND VPWR sky130_fd_sc_hd__dlygate4sd3_1
Xhold275 hold275/X _2565_/Q VPWR VGND VGND VPWR sky130_fd_sc_hd__dlygate4sd3_1
XFILLER_45_105 VPWR VGND VPWR VGND sky130_fd_sc_hd__decap_6
X_2574_ VGND VPWR VPWR VGND clkload1/A _2574_/D load_slew150/X _2574_/Q sky130_fd_sc_hd__dfrtp_1
X_1387_ VGND VPWR _1431_/B _1430_/B _1391_/B VPWR VGND sky130_fd_sc_hd__xnor2_1
X_1525_ VPWR VGND VGND VPWR _2626_/Q _1521_/B _1524_/Y _2627_/Q _1525_/Y sky130_fd_sc_hd__o22ai_1
X_1456_ VPWR VGND VGND VPWR _1657_/C _1375_/Y _1455_/B _1373_/X wire29/X _2442_/Q
+ sky130_fd_sc_hd__o41a_1
XFILLER_67_285 VGND VPWR VPWR VGND sky130_fd_sc_hd__decap_4
X_2008_ VPWR VGND VGND VPWR _2008_/A _2042_/B _2008_/Y sky130_fd_sc_hd__nor2_1
XFILLER_50_141 VGND VPWR VPWR VGND sky130_fd_sc_hd__decap_4
XFILLER_26_193 VPWR VGND VPWR VGND sky130_fd_sc_hd__decap_3
X_1241_ VPWR VGND VGND VPWR _2443_/Q _1241_/Y sky130_fd_sc_hd__inv_1
X_1310_ VGND VPWR VGND VPWR _1298_/Y _1299_/Y _1311_/B _1305_/B sky130_fd_sc_hd__o21ai_0
XFILLER_1_281 VPWR VGND VPWR VGND sky130_fd_sc_hd__decap_8
X_2290_ VPWR VGND VGND VPWR _2290_/C _2290_/B _2290_/A _2294_/A sky130_fd_sc_hd__nor3_1
X_2557_ VGND VPWR VPWR VGND _2607_/CLK _2557_/D _2494_/SET_B _2557_/Q sky130_fd_sc_hd__dfrtp_1
X_2626_ VGND VPWR VPWR VGND clkload3/A _2626_/D _2429_/SET_B _2626_/Q sky130_fd_sc_hd__dfrtp_1
X_2488_ VGND VPWR VPWR VGND _2634_/CLK _2488_/D load_slew175/X _2488_/Q sky130_fd_sc_hd__dfrtp_1
X_1508_ VPWR VGND VGND VPWR _2622_/Q _1523_/A _1503_/Y _1508_/Y _2621_/Q _1507_/Y
+ sky130_fd_sc_hd__o32ai_1
X_1439_ VPWR VGND VGND VPWR _1690_/A _1440_/B _1423_/Y _2478_/Q _1439_/Y sky130_fd_sc_hd__o22ai_1
Xmax_cap39 VGND VPWR VPWR VGND _1516_/B _1514_/A1 sky130_fd_sc_hd__clkdlybuf4s25_1
X_1790_ VPWR VGND VPWR VGND _1789_/X _2003_/S _1785_/Y _2493_/D sky130_fd_sc_hd__a21oi_1
X_2411_ VGND VPWR VPWR VGND _2592_/CLK _2411_/D load_slew147/X _2411_/Q sky130_fd_sc_hd__dfrtp_1
X_1224_ VPWR VGND VGND VPWR _2460_/Q _1224_/Y sky130_fd_sc_hd__inv_1
XFILLER_35_3 VPWR VGND VPWR VGND sky130_fd_sc_hd__decap_8
X_2273_ VGND VPWR _2283_/A _2275_/B _2273_/A VPWR VGND sky130_fd_sc_hd__xnor2_1
X_2342_ VPWR VGND VPWR VGND _2329_/Y _1557_/A _1466_/B _2342_/Y sky130_fd_sc_hd__a21oi_1
XFILLER_37_255 VPWR VGND VPWR VGND sky130_fd_sc_hd__decap_6
X_1988_ VGND VPWR VPWR VGND _2568_/D _2393_/Q _2020_/B hold294/X sky130_fd_sc_hd__mux2_1
X_2609_ VGND VPWR VPWR VGND clkload5/A _2609_/D load_slew162/X _2609_/Q sky130_fd_sc_hd__dfrtp_1
XFILLER_43_225 VGND VPWR VPWR VGND sky130_fd_sc_hd__decap_12
Xfanout190 VGND VPWR VGND VPWR fanout191/X fanout190/X sky130_fd_sc_hd__clkdlybuf4s50_1
XFILLER_19_255 VGND VPWR VPWR VGND sky130_fd_sc_hd__decap_4
X_1773_ VPWR VGND VPWR VGND _1770_/B _1770_/A _1768_/B _1777_/A sky130_fd_sc_hd__a21oi_1
X_1842_ VPWR VGND VGND VPWR _2513_/Q _1842_/Y _2587_/Q _1884_/S sky130_fd_sc_hd__mux2i_1
X_1911_ VPWR VGND VGND VPWR _2536_/Q _1911_/Y _2562_/Q _1971_/S sky130_fd_sc_hd__mux2i_1
XFILLER_6_181 VPWR VGND VPWR VGND sky130_fd_sc_hd__decap_6
X_2187_ VPWR VGND VGND VPWR _2189_/B _2475_/Q _2212_/B _2187_/B sky130_fd_sc_hd__maj3_1
X_2256_ VPWR VGND VPWR VGND _2255_/B _1688_/A _2255_/Y _2256_/Y sky130_fd_sc_hd__a21oi_1
X_2325_ VPWR VGND VPWR VGND _2323_/Y _2351_/B _2324_/Y _2325_/Y sky130_fd_sc_hd__a21oi_1
X_1207_ VPWR VGND VGND VPWR _2274_/A _2149_/B sky130_fd_sc_hd__inv_1
XFILLER_25_225 VPWR VGND VPWR VGND sky130_fd_sc_hd__decap_8
XFILLER_31_206 VPWR VGND VPWR VGND sky130_fd_sc_hd__decap_3
X_2041_ VPWR VGND VPWR VGND _2042_/B _1242_/Y _2040_/Y _2602_/D sky130_fd_sc_hd__a21oi_1
X_2110_ VPWR VGND VPWR VGND _2109_/X _2108_/Y _2110_/B1 _2417_/D sky130_fd_sc_hd__a21oi_1
X_1825_ VGND VPWR VPWR VGND _1825_/A _2506_/D _1825_/B sky130_fd_sc_hd__xor2_1
X_1756_ VPWR VGND VGND VPWR _1756_/A _1757_/B _1756_/B sky130_fd_sc_hd__nand2_1
XFILLER_30_283 VPWR VGND VPWR VGND sky130_fd_sc_hd__decap_6
X_1687_ VPWR VGND VPWR VGND _1686_/Y _1671_/Y _2136_/A _2477_/D sky130_fd_sc_hd__a21oi_1
X_2308_ VGND VPWR VGND VPWR _2288_/Y _2331_/A _2322_/B _1519_/A sky130_fd_sc_hd__o21ai_0
X_2239_ VPWR VGND VPWR VGND _2428_/D fanout3/X _2228_/Y _2238_/Y _2201_/A _2136_/A
+ sky130_fd_sc_hd__o32a_1
XFILLER_70_48 VPWR VGND VPWR VGND sky130_fd_sc_hd__decap_8
X_1610_ VPWR VGND VGND VPWR _1236_/Y _2448_/D _1609_/Y _1628_/S sky130_fd_sc_hd__mux2i_1
X_2590_ VGND VPWR VPWR VGND clkload2/A _2590_/D fanout156/X _2590_/Q sky130_fd_sc_hd__dfrtp_1
X_1472_ VPWR VGND VPWR VGND _1472_/A _1472_/C _1472_/D _1472_/Y _1495_/B sky130_fd_sc_hd__nand4_1
X_1541_ VPWR VGND VPWR VGND _2077_/B _2442_/Q _1561_/B _1541_/Y sky130_fd_sc_hd__a21oi_1
XFILLER_47_180 VPWR VGND VPWR VGND sky130_fd_sc_hd__decap_3
X_2024_ VPWR VGND VGND VPWR _2024_/A _2028_/B _2024_/Y sky130_fd_sc_hd__nor2_1
Xhold210 _2555_/D _1967_/Y VPWR VGND VGND VPWR sky130_fd_sc_hd__dlygate4sd3_1
X_1808_ VPWR VGND VGND VPWR _2487_/Q _2495_/Q _1809_/C sky130_fd_sc_hd__nor2b_1
Xhold243 _2529_/D _1889_/Y VPWR VGND VGND VPWR sky130_fd_sc_hd__dlygate4sd3_1
Xhold232 _1903_/A _2534_/Q VPWR VGND VGND VPWR sky130_fd_sc_hd__dlygate4sd3_1
Xhold287 _2040_/A _2602_/Q VPWR VGND VGND VPWR sky130_fd_sc_hd__dlygate4sd3_1
Xhold254 _2535_/D _1907_/Y VPWR VGND VGND VPWR sky130_fd_sc_hd__dlygate4sd3_1
Xhold265 _2514_/D _1844_/Y VPWR VGND VGND VPWR sky130_fd_sc_hd__dlygate4sd3_1
Xhold221 _1846_/A _2515_/Q VPWR VGND VGND VPWR sky130_fd_sc_hd__dlygate4sd3_1
X_1739_ VPWR VGND VGND VPWR _2121_/A _1739_/B _1740_/B sky130_fd_sc_hd__nor2_1
Xhold276 _2565_/D _1985_/X VPWR VGND VGND VPWR sky130_fd_sc_hd__dlygate4sd3_1
Xhold298 hold298/X _2582_/Q VPWR VGND VGND VPWR sky130_fd_sc_hd__dlygate4sd3_1
XFILLER_5_202 VGND VPWR VPWR VGND sky130_fd_sc_hd__decap_12
XFILLER_55_81 VPWR VGND VPWR VGND sky130_fd_sc_hd__decap_3
XFILLER_29_191 VPWR VGND VPWR VGND sky130_fd_sc_hd__decap_3
X_1524_ VPWR VGND VPWR VGND _1523_/Y _1486_/A _1486_/Y _1524_/Y sky130_fd_sc_hd__a21oi_1
X_2573_ VGND VPWR VPWR VGND clkload7/A _2573_/D load_slew144/X _2573_/Q sky130_fd_sc_hd__dfrtp_1
X_1386_ VPWR VGND VGND VPWR _1391_/B _1386_/Y _1431_/B sky130_fd_sc_hd__nand2_1
X_1455_ VPWR VGND VGND VPWR _2167_/A _1455_/B _1455_/Y sky130_fd_sc_hd__nor2_1
X_2007_ VPWR VGND VPWR VGND _2042_/B _1240_/Y _2006_/Y _2585_/D sky130_fd_sc_hd__a21oi_1
XFILLER_51_28 VGND VPWR VPWR VGND sky130_fd_sc_hd__decap_4
XFILLER_50_197 VPWR VGND VPWR VGND sky130_fd_sc_hd__decap_3
XFILLER_50_153 VGND VPWR VPWR VGND sky130_fd_sc_hd__decap_4
XFILLER_25_51 VGND VPWR VPWR VGND sky130_fd_sc_hd__decap_4
XFILLER_49_253 VGND VPWR VPWR VGND sky130_fd_sc_hd__decap_12
X_1240_ VPWR VGND VGND VPWR _2444_/Q _1240_/Y sky130_fd_sc_hd__inv_1
X_2556_ VGND VPWR VPWR VGND _2607_/CLK _2556_/D _2494_/SET_B _2556_/Q sky130_fd_sc_hd__dfrtp_1
X_1507_ VPWR VGND VGND VPWR _1507_/A _1507_/B _1507_/Y sky130_fd_sc_hd__nor2_1
X_2487_ VGND VPWR VPWR VGND clkload9/A _2487_/D load_slew166/X _2487_/Q sky130_fd_sc_hd__dfrtp_1
X_2625_ VGND VPWR VPWR VGND _2633_/CLK _2625_/D _2429_/SET_B _2625_/Q sky130_fd_sc_hd__dfrtp_1
XFILLER_55_234 VGND VPWR VPWR VGND sky130_fd_sc_hd__decap_4
X_1438_ VPWR VGND VPWR VGND _1423_/Y _2478_/Q _1437_/X _1438_/Y sky130_fd_sc_hd__a21oi_1
X_1369_ VPWR VGND VPWR VGND _1368_/X _1363_/Y _2332_/A _1369_/Y sky130_fd_sc_hd__a21oi_1
XFILLER_46_267 VGND VPWR VPWR VGND sky130_fd_sc_hd__decap_4
X_2410_ VGND VPWR VPWR VGND _2592_/CLK _2410_/D load_slew147/X _2410_/Q sky130_fd_sc_hd__dfrtp_1
X_2341_ VGND VPWR VGND VPWR _2340_/Y _2331_/A _2341_/Y _2351_/B sky130_fd_sc_hd__o21ai_0
X_1223_ VPWR VGND VGND VPWR _1223_/A _1539_/B sky130_fd_sc_hd__inv_1
X_2272_ VPWR VGND VGND VPWR _2272_/A _2272_/B _2290_/A sky130_fd_sc_hd__nor2_1
X_1987_ VGND VPWR VPWR VGND _2567_/D _2392_/Q _2020_/B hold280/X sky130_fd_sc_hd__mux2_1
XFILLER_20_189 VGND VPWR VPWR VGND sky130_fd_sc_hd__decap_4
X_2608_ VPWR VGND VPWR VGND _2608_/Q fanout157/A _2608_/D clkload5/A sky130_fd_sc_hd__dfstp_2
X_2539_ VGND VPWR VPWR VGND clkload5/A _2539_/D fanout155/X _2539_/Q sky130_fd_sc_hd__dfrtp_1
Xwire60 VGND VPWR VPWR VGND wire60/A wire60/X sky130_fd_sc_hd__clkdlybuf4s25_1
XFILLER_43_237 VGND VPWR VPWR VGND sky130_fd_sc_hd__decap_12
Xfanout191 VGND VPWR VGND VPWR fanout192/X fanout191/X sky130_fd_sc_hd__clkdlybuf4s50_1
Xfanout180 VGND VPWR VGND VPWR fanout182/X wire181/A sky130_fd_sc_hd__clkdlybuf4s50_1
XFILLER_19_245 VPWR VGND VPWR VGND sky130_fd_sc_hd__decap_3
X_1910_ VGND VPWR VGND VPWR _1909_/Y _1975_/B _1910_/Y _1908_/Y sky130_fd_sc_hd__o21ai_0
X_1772_ VPWR VGND VPWR VGND _1770_/Y _1999_/S _1771_/Y _2490_/D sky130_fd_sc_hd__a21oi_1
X_1841_ VGND VPWR VGND VPWR _1840_/Y _1951_/B _2513_/D _1839_/Y sky130_fd_sc_hd__o21ai_0
X_2324_ VGND VPWR VGND VPWR _2360_/A _2316_/A _2324_/Y _2351_/B sky130_fd_sc_hd__o21ai_0
X_2186_ VGND VPWR _2186_/B _2189_/A _2201_/C VPWR VGND sky130_fd_sc_hd__xnor2_1
X_2255_ VPWR VGND VGND VPWR _2255_/A _2255_/B _2255_/Y sky130_fd_sc_hd__nor2_1
X_1206_ VPWR VGND VGND VPWR _2483_/Q _2289_/A sky130_fd_sc_hd__inv_1
X_2040_ VPWR VGND VGND VPWR _2040_/A _2042_/B _2040_/Y sky130_fd_sc_hd__nor2_1
XFILLER_15_281 VPWR VGND VPWR VGND sky130_fd_sc_hd__decap_8
X_1824_ VGND VPWR VGND VPWR _1823_/Y _2633_/Q _2505_/D _1260_/Y sky130_fd_sc_hd__o21ai_0
X_1686_ VPWR VGND VGND VPWR _1688_/B _1686_/Y _1686_/B sky130_fd_sc_hd__nand2_1
X_1755_ VPWR VGND VGND VPWR _2123_/B _1755_/B _1756_/B _1755_/C sky130_fd_sc_hd__nand3_1
XFILLER_57_104 VGND VPWR VPWR VGND sky130_fd_sc_hd__decap_4
X_2238_ VPWR VGND VPWR VGND _2236_/Y _2283_/B _2237_/Y _2238_/Y sky130_fd_sc_hd__a21oi_1
X_2307_ VGND VPWR _2307_/B _2322_/A _2307_/A VPWR VGND sky130_fd_sc_hd__xnor2_1
X_2169_ VGND VPWR VPWR VGND _2198_/B _2171_/B _2474_/Q sky130_fd_sc_hd__xor2_1
XFILLER_0_133 VPWR VGND VPWR VGND sky130_fd_sc_hd__decap_6
XFILLER_28_40 VGND VPWR VPWR VGND sky130_fd_sc_hd__decap_12
X_1540_ VPWR VGND VPWR VGND _2167_/A _1561_/B _2442_/Q _1540_/X sky130_fd_sc_hd__or3_1
X_1471_ VPWR VGND VGND VPWR _1472_/D _2230_/B _2255_/A _2230_/A _2242_/A sky130_fd_sc_hd__nor4_1
X_2023_ VPWR VGND VPWR VGND _2028_/B _1232_/Y _2022_/Y _2593_/D sky130_fd_sc_hd__a21oi_1
X_1807_ VGND VPWR _1807_/B _2502_/D _1807_/A VPWR VGND sky130_fd_sc_hd__xnor2_1
XPHY_EDGE_ROW_17_Left_88 VPWR VGND VPWR VGND sky130_fd_sc_hd__decap_3
Xhold277 hold277/X _2581_/Q VPWR VGND VGND VPWR sky130_fd_sc_hd__dlygate4sd3_1
Xhold200 _1897_/A _2532_/Q VPWR VGND VGND VPWR sky130_fd_sc_hd__dlygate4sd3_1
XFILLER_49_39 VGND VPWR VPWR VGND sky130_fd_sc_hd__decap_12
Xhold233 _2534_/D _1904_/Y VPWR VGND VGND VPWR sky130_fd_sc_hd__dlygate4sd3_1
Xhold244 _1882_/A _2527_/Q VPWR VGND VGND VPWR sky130_fd_sc_hd__dlygate4sd3_1
Xhold288 hold288/X _2576_/Q VPWR VGND VGND VPWR sky130_fd_sc_hd__dlygate4sd3_1
Xhold255 _1909_/A _2536_/Q VPWR VGND VGND VPWR sky130_fd_sc_hd__dlygate4sd3_1
Xhold211 _1876_/A _2525_/Q VPWR VGND VGND VPWR sky130_fd_sc_hd__dlygate4sd3_1
Xhold222 _1933_/A _2544_/Q VPWR VGND VGND VPWR sky130_fd_sc_hd__dlygate4sd3_1
X_1669_ VPWR VGND VGND VPWR _2483_/Q _2274_/A _1702_/B _1697_/B sky130_fd_sc_hd__nand3_1
Xhold266 _1945_/A _2548_/Q VPWR VGND VGND VPWR sky130_fd_sc_hd__dlygate4sd3_1
X_1738_ VPWR VGND VGND VPWR _2457_/Q _2399_/Q _2456_/Q _2398_/Q _1739_/B sky130_fd_sc_hd__o22ai_1
Xhold299 _2016_/A _2590_/Q VPWR VGND VGND VPWR sky130_fd_sc_hd__dlygate4sd3_1
XFILLER_30_85 VPWR VGND VPWR VGND sky130_fd_sc_hd__decap_3
X_1523_ VPWR VGND VGND VPWR _1523_/A _1523_/B _1523_/Y sky130_fd_sc_hd__nor2_1
X_2572_ VGND VPWR VPWR VGND clkload1/A _2572_/D load_slew144/X _2572_/Q sky130_fd_sc_hd__dfrtp_1
X_1454_ VGND VPWR VGND VPWR _1454_/X _1451_/Y _1452_/Y _1414_/Y _1470_/B sky130_fd_sc_hd__a211o_1
XFILLER_67_221 VPWR VGND VPWR VGND sky130_fd_sc_hd__decap_3
XFILLER_67_210 VPWR VGND VPWR VGND sky130_fd_sc_hd__decap_3
X_1385_ VGND VPWR VPWR VGND _2213_/B _1429_/A _1389_/B sky130_fd_sc_hd__xor2_1
X_2006_ VPWR VGND VGND VPWR _2006_/A _2010_/B _2006_/Y sky130_fd_sc_hd__nor2_1
XFILLER_25_63 VGND VPWR VPWR VGND sky130_fd_sc_hd__decap_4
XFILLER_41_51 VGND VPWR VPWR VGND sky130_fd_sc_hd__decap_4
XFILLER_66_70 VPWR VGND VPWR VGND sky130_fd_sc_hd__decap_8
XFILLER_49_265 VPWR VGND VPWR VGND sky130_fd_sc_hd__decap_8
XFILLER_64_257 VGND VPWR VPWR VGND sky130_fd_sc_hd__decap_4
XFILLER_32_121 VPWR VGND VPWR VGND sky130_fd_sc_hd__decap_3
XFILLER_17_162 VPWR VGND VPWR VGND sky130_fd_sc_hd__decap_6
X_2624_ VGND VPWR VPWR VGND _2633_/CLK _2624_/D fanout183/A _2624_/Q sky130_fd_sc_hd__dfrtp_1
X_2555_ VGND VPWR VPWR VGND _2634_/CLK _2555_/D fanout182/X _2555_/Q sky130_fd_sc_hd__dfrtp_1
X_1506_ VPWR VGND VPWR VGND _1477_/B _1477_/A _1303_/A _1507_/B sky130_fd_sc_hd__a21oi_1
X_1437_ VPWR VGND VGND VPWR _1437_/X _1437_/C _2477_/Q _1437_/B sky130_fd_sc_hd__maj3_1
XPHY_EDGE_ROW_34_Left_105 VPWR VGND VPWR VGND sky130_fd_sc_hd__decap_3
X_2486_ VGND VPWR VPWR VGND clkload4/A _2486_/D _2437_/SET_B _2486_/Q sky130_fd_sc_hd__dfrtp_1
XFILLER_55_202 VPWR VGND VPWR VGND sky130_fd_sc_hd__decap_3
X_1299_ VPWR VGND VGND VPWR _2255_/A _2242_/B _1299_/Y sky130_fd_sc_hd__nor2_1
Xmax_cap19 VGND VPWR _2080_/B _2052_/B VPWR VGND sky130_fd_sc_hd__buf_1
X_1368_ VGND VPWR VGND VPWR _1368_/B _2318_/A _1368_/X sky130_fd_sc_hd__or2_0
XPHY_EDGE_ROW_43_Left_114 VPWR VGND VPWR VGND sky130_fd_sc_hd__decap_3
XPHY_EDGE_ROW_52_Left_123 VPWR VGND VPWR VGND sky130_fd_sc_hd__decap_3
XPHY_EDGE_ROW_61_Left_132 VPWR VGND VPWR VGND sky130_fd_sc_hd__decap_3
XPHY_EDGE_ROW_70_Left_141 VPWR VGND VPWR VGND sky130_fd_sc_hd__decap_3
X_2271_ VPWR VGND VPWR VGND _2255_/B _2232_/A _2270_/Y _2271_/Y sky130_fd_sc_hd__a21oi_1
X_2340_ VPWR VGND VPWR VGND _2339_/X _2351_/B _1557_/A _2340_/Y sky130_fd_sc_hd__a21oi_1
X_1222_ VPWR VGND VGND VPWR _1222_/A _2634_/D sky130_fd_sc_hd__inv_1
XFILLER_20_113 VPWR VGND VPWR VGND sky130_fd_sc_hd__decap_8
X_1986_ VGND VPWR VPWR VGND _1986_/X _2391_/Q _2034_/B hold269/X sky130_fd_sc_hd__mux2_1
X_2607_ VGND VPWR VPWR VGND _2607_/CLK _2607_/D fanout187/A _2607_/Q sky130_fd_sc_hd__dfrtp_1
Xclkbuf_leaf_9_clk VGND VPWR VGND VPWR clkbuf_leaf_9_clk/A clkload3/A sky130_fd_sc_hd__clkbuf_16
X_2538_ VGND VPWR VPWR VGND clkload5/A _2538_/D fanout155/X _2538_/Q sky130_fd_sc_hd__dfrtp_1
X_2469_ VGND VPWR VPWR VGND clkload5/A _2469_/D load_slew154/X _2469_/Q sky130_fd_sc_hd__dfrtp_1
XFILLER_43_249 VGND VPWR VPWR VGND sky130_fd_sc_hd__decap_12
XFILLER_43_205 VPWR VGND VPWR VGND sky130_fd_sc_hd__decap_8
Xwire72 VGND VPWR wire72/A mute VPWR VGND sky130_fd_sc_hd__clkbuf_4
XFILLER_11_179 VPWR VGND VPWR VGND sky130_fd_sc_hd__decap_3
XFILLER_22_53 VPWR VGND VPWR VGND sky130_fd_sc_hd__decap_6
XPHY_EDGE_ROW_5_Left_76 VPWR VGND VPWR VGND sky130_fd_sc_hd__decap_3
Xfanout192 VGND VPWR VGND VPWR input1/X fanout192/X sky130_fd_sc_hd__clkdlybuf4s50_1
X_1840_ VPWR VGND VGND VPWR _1840_/A _1840_/Y _1909_/B sky130_fd_sc_hd__nand2_1
X_1771_ VPWR VGND VGND VPWR _1771_/A _1999_/S _1771_/Y sky130_fd_sc_hd__nor2_1
X_2254_ VPWR VGND VGND VPWR _2429_/D _2253_/Y _2136_/Y _2254_/B2 _2241_/B sky130_fd_sc_hd__a2bb2oi_1
XFILLER_40_3 VGND VPWR VPWR VGND sky130_fd_sc_hd__decap_12
X_2323_ VGND VPWR _2323_/B _2323_/Y _2323_/A VPWR VGND sky130_fd_sc_hd__xnor2_1
X_2185_ VGND VPWR _2185_/B _2186_/B _2201_/A VPWR VGND sky130_fd_sc_hd__xnor2_1
X_1205_ VPWR VGND VGND VPWR _2484_/Q _2307_/A sky130_fd_sc_hd__inv_1
XFILLER_25_216 VPWR VGND VPWR VGND sky130_fd_sc_hd__decap_8
X_1969_ VPWR VGND VGND VPWR _1969_/A _1969_/Y _1969_/B sky130_fd_sc_hd__nand2_1
XFILLER_16_216 VGND VPWR VPWR VGND sky130_fd_sc_hd__decap_4
X_1823_ VPWR VGND VGND VPWR _2633_/Q _1975_/A _1823_/Y _1833_/A sky130_fd_sc_hd__nand3_1
X_1754_ VGND VPWR VGND VPWR _1754_/B _2119_/A _1757_/A sky130_fd_sc_hd__or2_0
X_1685_ VPWR VGND VGND VPWR _2200_/A _1686_/B _1685_/B sky130_fd_sc_hd__nand2_1
X_2237_ VGND VPWR VGND VPWR _1256_/Y _2230_/B _2237_/Y _2283_/B sky130_fd_sc_hd__o21ai_0
X_2306_ VPWR VGND VGND VPWR _2484_/Q _2306_/Y _2307_/B sky130_fd_sc_hd__nand2_1
X_2099_ VGND VPWR VGND VPWR _2414_/Q _2114_/C _2099_/Y _2102_/D sky130_fd_sc_hd__o21ai_0
X_2168_ VPWR VGND VGND VPWR _2168_/A _2297_/A _2168_/B sky130_fd_sc_hd__nand2_1
XPHY_EDGE_ROW_17_Right_17 VPWR VGND VPWR VGND sky130_fd_sc_hd__decap_3
XPHY_EDGE_ROW_26_Right_26 VPWR VGND VPWR VGND sky130_fd_sc_hd__decap_3
XFILLER_28_52 VGND VPWR VPWR VGND sky130_fd_sc_hd__decap_4
XFILLER_28_85 VPWR VGND VPWR VGND sky130_fd_sc_hd__decap_3
XPHY_EDGE_ROW_35_Right_35 VPWR VGND VPWR VGND sky130_fd_sc_hd__decap_3
XFILLER_60_94 VGND VPWR VPWR VGND sky130_fd_sc_hd__decap_4
XFILLER_8_278 VPWR VGND VPWR VGND sky130_fd_sc_hd__decap_8
X_1470_ VPWR VGND VGND VPWR _1470_/C _1470_/B _2351_/A _1472_/C sky130_fd_sc_hd__nor3_1
XPHY_EDGE_ROW_44_Right_44 VPWR VGND VPWR VGND sky130_fd_sc_hd__decap_3
XPHY_EDGE_ROW_53_Right_53 VPWR VGND VPWR VGND sky130_fd_sc_hd__decap_3
X_2022_ VPWR VGND VGND VPWR _2022_/A _2028_/B _2022_/Y sky130_fd_sc_hd__nor2_1
X_1806_ VGND VPWR _1806_/B _2501_/D _1806_/A VPWR VGND sky130_fd_sc_hd__xnor2_1
Xhold201 _2532_/D _1898_/Y VPWR VGND VGND VPWR sky130_fd_sc_hd__dlygate4sd3_1
XPHY_EDGE_ROW_62_Right_62 VPWR VGND VPWR VGND sky130_fd_sc_hd__decap_3
Xhold212 _1885_/A _2528_/Q VPWR VGND VGND VPWR sky130_fd_sc_hd__dlygate4sd3_1
Xhold289 hold289/X _2561_/Q VPWR VGND VGND VPWR sky130_fd_sc_hd__dlygate4sd3_1
Xhold245 _2527_/D _1883_/Y VPWR VGND VGND VPWR sky130_fd_sc_hd__dlygate4sd3_1
Xhold256 _2536_/D _1910_/Y VPWR VGND VGND VPWR sky130_fd_sc_hd__dlygate4sd3_1
X_1599_ VPWR VGND VGND VPWR _1599_/C _1600_/B _1603_/A _2630_/D sky130_fd_sc_hd__nor3_1
Xhold223 _2544_/D _1934_/Y VPWR VGND VGND VPWR sky130_fd_sc_hd__dlygate4sd3_1
Xhold278 hold278/X _2572_/Q VPWR VGND VGND VPWR sky130_fd_sc_hd__dlygate4sd3_1
X_1668_ VPWR VGND VGND VPWR _2274_/A _1699_/B _1697_/B sky130_fd_sc_hd__nand2_1
Xhold267 _2548_/D _1946_/Y VPWR VGND VGND VPWR sky130_fd_sc_hd__dlygate4sd3_1
Xhold234 _1852_/A _2517_/Q VPWR VGND VGND VPWR sky130_fd_sc_hd__dlygate4sd3_1
X_1737_ VPWR VGND VPWR VGND _2399_/Q _2457_/Q _1740_/A _2458_/Q _2400_/Q sky130_fd_sc_hd__a22oi_1
Xload_slew170 VPWR VGND load_slew170/X fanout169/X VPWR VGND sky130_fd_sc_hd__buf_2
XFILLER_38_182 VGND VPWR VPWR VGND sky130_fd_sc_hd__decap_4
XFILLER_14_65 VPWR VGND VPWR VGND sky130_fd_sc_hd__decap_8
X_1522_ VGND VPWR VGND VPWR _2625_/Q _1523_/A _1522_/Y _1515_/Y sky130_fd_sc_hd__o21ai_0
X_2571_ VGND VPWR VPWR VGND clkload1/A _2571_/D fanout145/X _2571_/Q sky130_fd_sc_hd__dfrtp_1
X_1453_ VPWR VGND VPWR VGND _1451_/Y _1414_/Y _1455_/B _1452_/Y _1470_/B sky130_fd_sc_hd__a211oi_2
XFILLER_67_277 VPWR VGND VPWR VGND sky130_fd_sc_hd__decap_3
X_2005_ VPWR VGND VPWR VGND _2010_/B _1241_/Y _2004_/Y _2584_/D sky130_fd_sc_hd__a21oi_1
X_1384_ VGND VPWR VPWR VGND _2283_/A _1423_/A _2242_/B sky130_fd_sc_hd__xor2_1
XFILLER_26_141 VPWR VGND VPWR VGND sky130_fd_sc_hd__decap_6
XFILLER_41_155 VPWR VGND VPWR VGND sky130_fd_sc_hd__decap_8
X_2554_ VGND VPWR VPWR VGND _2634_/CLK _2554_/D load_slew177/X _2554_/Q sky130_fd_sc_hd__dfrtp_1
X_2623_ VGND VPWR VPWR VGND _2633_/CLK _2623_/D fanout183/A _2623_/Q sky130_fd_sc_hd__dfrtp_1
X_1505_ VPWR VGND VPWR VGND _1503_/Y _2621_/Q _1504_/X _1505_/Y sky130_fd_sc_hd__a21oi_1
X_1436_ VPWR VGND VGND VPWR _1437_/C _1436_/C _2476_/Q _1436_/B sky130_fd_sc_hd__maj3_1
X_2485_ VGND VPWR VPWR VGND clkload4/A _2485_/D fanout159/A _2485_/Q sky130_fd_sc_hd__dfrtp_1
X_1367_ VPWR VGND VPWR VGND _1350_/X _1356_/X _1374_/A _1363_/Y _2332_/A _1365_/X
+ sky130_fd_sc_hd__a221o_1
XFILLER_55_247 VGND VPWR VPWR VGND sky130_fd_sc_hd__decap_12
X_1298_ VPWR VGND VGND VPWR _2255_/A _1298_/Y _2242_/B sky130_fd_sc_hd__nand2_1
X_2270_ VGND VPWR VGND VPWR _2173_/A _2283_/A _2270_/Y _2255_/B sky130_fd_sc_hd__o21ai_0
X_1221_ VPWR VGND VGND VPWR _2442_/Q _1221_/Y sky130_fd_sc_hd__inv_1
XFILLER_37_214 VPWR VGND VPWR VGND sky130_fd_sc_hd__decap_3
X_1985_ VGND VPWR VPWR VGND _1985_/X _2390_/Q _2034_/B hold275/X sky130_fd_sc_hd__mux2_1
X_2606_ VGND VPWR VPWR VGND _2606_/CLK _2606_/D wire181/X _2606_/Q sky130_fd_sc_hd__dfrtp_1
X_2537_ VGND VPWR VPWR VGND clkload5/A _2537_/D load_slew162/X _2537_/Q sky130_fd_sc_hd__dfrtp_1
XPHY_EDGE_ROW_21_Left_92 VPWR VGND VPWR VGND sky130_fd_sc_hd__decap_3
X_2468_ VGND VPWR VPWR VGND _2592_/CLK _2468_/D load_slew154/X _2468_/Q sky130_fd_sc_hd__dfrtp_1
X_2399_ VGND VPWR VPWR VGND clkload1/A _2399_/D load_slew150/X _2399_/Q sky130_fd_sc_hd__dfrtp_1
X_1419_ VPWR VGND VGND VPWR _2289_/A _1419_/B _1419_/Y sky130_fd_sc_hd__nor2_1
XFILLER_51_250 VPWR VGND VPWR VGND sky130_fd_sc_hd__decap_8
XFILLER_11_169 VGND VPWR VPWR VGND sky130_fd_sc_hd__decap_4
XFILLER_0_3 VGND VPWR VPWR VGND sky130_fd_sc_hd__decap_12
Xfanout182 VGND VPWR VGND VPWR fanout191/X fanout182/X sky130_fd_sc_hd__clkdlybuf4s50_1
Xfanout171 VGND VPWR VGND VPWR fanout173/X fanout171/X sky130_fd_sc_hd__clkdlybuf4s50_1
XFILLER_34_228 VGND VPWR VPWR VGND sky130_fd_sc_hd__decap_4
XFILLER_19_203 VGND VPWR VPWR VGND sky130_fd_sc_hd__decap_12
XFILLER_19_225 VGND VPWR VPWR VGND sky130_fd_sc_hd__decap_12
X_1770_ VGND VPWR _1770_/B _1770_/Y _1770_/A VPWR VGND sky130_fd_sc_hd__xnor2_1
XFILLER_10_191 VGND VPWR VPWR VGND sky130_fd_sc_hd__decap_4
X_2184_ VPWR VGND VPWR VGND _2286_/S _1215_/Y _2183_/Y _2184_/Y sky130_fd_sc_hd__a21oi_1
X_2253_ VPWR VGND VGND VPWR _1256_/Y _2240_/Y _2251_/Y _2252_/Y _2253_/Y sky130_fd_sc_hd__o22ai_1
X_1204_ VPWR VGND VGND VPWR _2332_/A _2333_/A sky130_fd_sc_hd__inv_1
X_2322_ VPWR VGND VGND VPWR _2323_/B _2322_/C _2322_/A _2322_/B sky130_fd_sc_hd__maj3_1
X_1968_ VPWR VGND VGND VPWR _1966_/A _1968_/Y _2581_/Q _1971_/S sky130_fd_sc_hd__mux2i_1
X_1899_ VPWR VGND VGND VPWR _2532_/Q _1899_/Y _2606_/Q _1902_/S sky130_fd_sc_hd__mux2i_1
X_1822_ VGND VPWR VPWR VGND _1822_/A _2504_/D _1831_/A sky130_fd_sc_hd__xor2_1
X_1753_ VGND VPWR VPWR VGND _1754_/B _2403_/Q _2461_/Q sky130_fd_sc_hd__and2_0
XFILLER_30_231 VGND VPWR VPWR VGND sky130_fd_sc_hd__decap_12
X_1684_ VPWR VGND VPWR VGND _1683_/Y _1671_/Y _2136_/A _2476_/D sky130_fd_sc_hd__a21oi_1
X_2236_ VGND VPWR _2236_/B _2236_/Y _2236_/A VPWR VGND sky130_fd_sc_hd__xnor2_1
X_2167_ VGND VPWR VPWR VGND _2167_/X _2168_/B _2167_/A sky130_fd_sc_hd__and2_0
X_2305_ VGND VPWR _2305_/B _2307_/B _2351_/A VPWR VGND sky130_fd_sc_hd__xnor2_1
XFILLER_70_29 VGND VPWR VPWR VGND sky130_fd_sc_hd__decap_12
X_2098_ VPWR VGND VPWR VGND _2442_/Q _2098_/D _2167_/A _2101_/A _2108_/C sky130_fd_sc_hd__or4_1
XFILLER_21_231 VPWR VGND VPWR VGND sky130_fd_sc_hd__decap_8
XFILLER_0_113 VGND VPWR VPWR VGND sky130_fd_sc_hd__decap_12
XFILLER_56_161 VPWR VGND VPWR VGND sky130_fd_sc_hd__decap_8
XFILLER_47_172 VPWR VGND VPWR VGND sky130_fd_sc_hd__decap_8
XFILLER_39_106 VPWR VGND VPWR VGND sky130_fd_sc_hd__decap_6
X_2021_ VPWR VGND VPWR VGND _2020_/B _1233_/Y _2020_/Y _2592_/D sky130_fd_sc_hd__a21oi_1
X_1805_ VPWR VGND VPWR VGND _2499_/Q _2501_/Q _1805_/D _1807_/B _2500_/Q sky130_fd_sc_hd__nand4_1
Xhold202 _1960_/A _2553_/Q VPWR VGND VGND VPWR sky130_fd_sc_hd__dlygate4sd3_1
Xhold213 _2528_/D _1886_/Y VPWR VGND VGND VPWR sky130_fd_sc_hd__dlygate4sd3_1
Xhold235 _1879_/A _2526_/Q VPWR VGND VGND VPWR sky130_fd_sc_hd__dlygate4sd3_1
Xhold224 _1861_/A _2520_/Q VPWR VGND VGND VPWR sky130_fd_sc_hd__dlygate4sd3_1
X_1736_ VPWR VGND VGND VPWR _2455_/Q _2397_/Q _2121_/B sky130_fd_sc_hd__nor2_1
Xhold246 _1972_/A _2557_/Q VPWR VGND VGND VPWR sky130_fd_sc_hd__dlygate4sd3_1
Xhold257 _2046_/A _2605_/Q VPWR VGND VGND VPWR sky130_fd_sc_hd__dlygate4sd3_1
X_1598_ VPWR VGND VGND VPWR _2630_/Q _1598_/B _1599_/C sky130_fd_sc_hd__nor2_1
Xhold268 _1858_/A _2519_/Q VPWR VGND VGND VPWR sky130_fd_sc_hd__dlygate4sd3_1
Xhold279 _2572_/D _1992_/X VPWR VGND VGND VPWR sky130_fd_sc_hd__dlygate4sd3_1
Xload_slew160 VPWR VGND fanout157/A fanout159/X VPWR VGND sky130_fd_sc_hd__buf_2
X_1667_ VPWR VGND VGND VPWR _2259_/A _1695_/B _1697_/B sky130_fd_sc_hd__nor2_1
X_2219_ VPWR VGND VGND VPWR _2219_/A _2229_/A sky130_fd_sc_hd__inv_1
XFILLER_39_74 VPWR VGND VPWR VGND sky130_fd_sc_hd__decap_6
XFILLER_29_183 VPWR VGND VPWR VGND sky130_fd_sc_hd__decap_3
X_2570_ VGND VPWR VPWR VGND clkload6/A _2570_/D fanout145/X _2570_/Q sky130_fd_sc_hd__dfrtp_1
X_1383_ VPWR VGND VGND VPWR _2283_/A _2242_/B _1383_/Y sky130_fd_sc_hd__nor2_1
X_1521_ VPWR VGND VGND VPWR _2626_/Q _1521_/Y _1521_/B sky130_fd_sc_hd__nand2_1
X_1452_ VPWR VGND VGND VPWR _1352_/Y _1415_/A _1414_/B _2332_/A _1452_/Y sky130_fd_sc_hd__o22ai_1
X_2004_ VPWR VGND VGND VPWR _2004_/A _2010_/B _2004_/Y sky130_fd_sc_hd__nor2_1
XFILLER_50_178 VGND VPWR VPWR VGND sky130_fd_sc_hd__decap_12
X_1719_ VPWR VGND VPWR VGND _2387_/Q _2445_/Q _1719_/Y _2446_/Q _2388_/Q sky130_fd_sc_hd__a22oi_1
XFILLER_58_223 VPWR VGND VPWR VGND sky130_fd_sc_hd__decap_3
XFILLER_25_32 VPWR VGND VPWR VGND sky130_fd_sc_hd__decap_8
XFILLER_26_197 VPWR VGND VPWR VGND sky130_fd_sc_hd__decap_3
XFILLER_41_178 VGND VPWR VPWR VGND sky130_fd_sc_hd__decap_12
XFILLER_2_25 VPWR VGND VPWR VGND sky130_fd_sc_hd__decap_3
XFILLER_66_50 VGND VPWR VPWR VGND sky130_fd_sc_hd__decap_4
XFILLER_17_175 VGND VPWR VPWR VGND sky130_fd_sc_hd__decap_4
X_2553_ VGND VPWR VPWR VGND _2634_/CLK _2553_/D load_slew177/X _2553_/Q sky130_fd_sc_hd__dfrtp_1
X_1504_ VPWR VGND VGND VPWR _1504_/X _1504_/C _2620_/Q _1504_/B sky130_fd_sc_hd__maj3_1
X_2622_ VGND VPWR VPWR VGND _2633_/CLK _2622_/D fanout183/A _2622_/Q sky130_fd_sc_hd__dfrtp_1
X_1435_ VPWR VGND VGND VPWR _1436_/C _1435_/C _2475_/Q _1435_/B sky130_fd_sc_hd__maj3_1
X_2484_ VGND VPWR VPWR VGND clkload4/A _2484_/D fanout159/A _2484_/Q sky130_fd_sc_hd__dfrtp_1
X_1366_ VGND VPWR VPWR VGND wire29/A _1363_/Y _1365_/X _1350_/X _1356_/X _2332_/A
+ sky130_fd_sc_hd__a221oi_1
X_1297_ VGND VPWR VGND VPWR _2475_/Q _1289_/X _1297_/Y _1290_/Y sky130_fd_sc_hd__o21ai_0
XFILLER_55_259 VPWR VGND VPWR VGND sky130_fd_sc_hd__decap_8
XFILLER_46_237 VPWR VGND VPWR VGND sky130_fd_sc_hd__decap_3
XFILLER_46_204 VPWR VGND VPWR VGND sky130_fd_sc_hd__decap_8
XFILLER_14_145 VPWR VGND VPWR VGND sky130_fd_sc_hd__decap_6
X_1220_ VPWR VGND VGND VPWR _2411_/Q _1262_/C sky130_fd_sc_hd__inv_1
XFILLER_45_270 VPWR VGND VPWR VGND sky130_fd_sc_hd__decap_3
XFILLER_60_273 VPWR VGND VPWR VGND sky130_fd_sc_hd__decap_8
X_1984_ VGND VPWR VPWR VGND _2564_/D _2389_/Q _2034_/B hold261/X sky130_fd_sc_hd__mux2_1
X_2605_ VGND VPWR VPWR VGND _2606_/CLK _2605_/D wire181/X _2605_/Q sky130_fd_sc_hd__dfrtp_1
X_2536_ VGND VPWR VPWR VGND clkload8/A _2536_/D _2429_/SET_B _2536_/Q sky130_fd_sc_hd__dfrtp_1
X_2467_ VGND VPWR VPWR VGND clkload5/A _2467_/D load_slew154/X _2467_/Q sky130_fd_sc_hd__dfrtp_1
X_1349_ VPWR VGND VPWR VGND _1338_/Y _1334_/Y _1348_/Y _1349_/Y sky130_fd_sc_hd__a21oi_1
X_2398_ VGND VPWR VPWR VGND clkload1/A _2398_/D load_slew144/X _2398_/Q sky130_fd_sc_hd__dfrtp_1
X_1418_ VGND VPWR _1418_/B _1419_/B _1418_/A VPWR VGND sky130_fd_sc_hd__xnor2_1
Xfanout183 VGND VPWR VGND VPWR fanout183/A fanout183/X sky130_fd_sc_hd__clkdlybuf4s50_1
Xfanout161 VGND VPWR VGND VPWR fanout163/X fanout161/X sky130_fd_sc_hd__clkdlybuf4s50_1
XFILLER_19_237 VPWR VGND VPWR VGND sky130_fd_sc_hd__decap_8
X_2321_ VPWR VGND VGND VPWR _2320_/Y _2321_/A _2323_/A sky130_fd_sc_hd__nor2b_1
X_2183_ VGND VPWR VGND VPWR _2365_/B1 _1389_/B _2183_/Y _2286_/S sky130_fd_sc_hd__o21ai_0
X_2252_ VGND VPWR VGND VPWR _1256_/Y _2198_/A _2252_/Y _2283_/B sky130_fd_sc_hd__o21ai_0
X_1203_ VPWR VGND VGND VPWR _2331_/B _2330_/B sky130_fd_sc_hd__inv_1
XFILLER_26_3 VPWR VGND VPWR VGND sky130_fd_sc_hd__decap_8
X_1967_ VGND VPWR VGND VPWR _1966_/Y _1966_/B _1967_/Y _1965_/Y sky130_fd_sc_hd__o21ai_0
X_1898_ VGND VPWR VGND VPWR _1897_/Y _1969_/B _1898_/Y _1896_/Y sky130_fd_sc_hd__o21ai_0
X_2519_ VGND VPWR VPWR VGND _2592_/CLK _2519_/D load_slew147/X _2519_/Q sky130_fd_sc_hd__dfrtp_1
XFILLER_17_44 VPWR VGND VPWR VGND sky130_fd_sc_hd__decap_3
XPHY_EDGE_ROW_49_Left_120 VPWR VGND VPWR VGND sky130_fd_sc_hd__decap_3
XFILLER_15_240 VPWR VGND VPWR VGND sky130_fd_sc_hd__decap_8
X_1821_ VPWR VGND VGND VPWR _1833_/A _1829_/B _1831_/A sky130_fd_sc_hd__nor2_1
Xmax_cap103 VPWR VGND i2s_ws _2504_/Q VPWR VGND sky130_fd_sc_hd__buf_4
X_1752_ VGND VPWR VGND VPWR _2403_/Q _2461_/Q _1752_/X sky130_fd_sc_hd__or2_0
X_1683_ VPWR VGND VGND VPWR _1685_/B _1683_/Y _1683_/B sky130_fd_sc_hd__nand2_1
XFILLER_30_243 VGND VPWR VPWR VGND sky130_fd_sc_hd__decap_4
Xclkbuf_leaf_10_clk VGND VPWR VGND VPWR clkbuf_leaf_9_clk/A clkload4/A sky130_fd_sc_hd__clkbuf_16
X_2304_ VPWR VGND VGND VPWR _2351_/A _2305_/B _2304_/Y sky130_fd_sc_hd__nand2b_1
X_2166_ VPWR VGND VPWR VGND _2255_/B _1216_/Y _2165_/Y _2166_/Y sky130_fd_sc_hd__a21oi_1
X_2235_ VPWR VGND VGND VPWR _2234_/X _2235_/A _2236_/B sky130_fd_sc_hd__nor2b_1
X_2097_ VGND VPWR VGND VPWR _2442_/Q _2098_/D wire16/A _2101_/A _2167_/A sky130_fd_sc_hd__nor4_2
XPHY_EDGE_ROW_3_Right_3 VPWR VGND VPWR VGND sky130_fd_sc_hd__decap_3
Xclkbuf_1_1__f_clk VGND VPWR VGND VPWR clkbuf_0_clk/X clkload0/A sky130_fd_sc_hd__clkbuf_16
XFILLER_0_169 VGND VPWR VPWR VGND sky130_fd_sc_hd__decap_12
XFILLER_44_20 VPWR VGND VPWR VGND sky130_fd_sc_hd__decap_8
X_2020_ VPWR VGND VGND VPWR _2020_/A _2020_/B _2020_/Y sky130_fd_sc_hd__nor2_1
X_1804_ VGND VPWR _1804_/B _2500_/D _1804_/A VPWR VGND sky130_fd_sc_hd__xnor2_1
Xhold247 _2557_/D _1973_/Y VPWR VGND VGND VPWR sky130_fd_sc_hd__dlygate4sd3_1
Xhold203 _2553_/D _1961_/Y VPWR VGND VGND VPWR sky130_fd_sc_hd__dlygate4sd3_1
Xhold214 _1891_/A _2530_/Q VPWR VGND VGND VPWR sky130_fd_sc_hd__dlygate4sd3_1
Xhold236 _2526_/D _1880_/Y VPWR VGND VGND VPWR sky130_fd_sc_hd__dlygate4sd3_1
Xhold225 _1918_/A _2539_/Q VPWR VGND VGND VPWR sky130_fd_sc_hd__dlygate4sd3_1
Xhold269 hold269/X _2566_/Q VPWR VGND VGND VPWR sky130_fd_sc_hd__dlygate4sd3_1
X_1666_ VPWR VGND VGND VPWR _2480_/Q _1690_/A _1695_/B _1690_/B sky130_fd_sc_hd__nand3_1
X_1735_ VPWR VGND VGND VPWR _2458_/Q _2400_/Q _2121_/A sky130_fd_sc_hd__nor2_1
Xhold258 _1849_/A _2516_/Q VPWR VGND VGND VPWR sky130_fd_sc_hd__dlygate4sd3_1
Xload_slew172 VPWR VGND load_slew172/X fanout171/X VPWR VGND sky130_fd_sc_hd__buf_4
X_1597_ VGND VPWR VPWR VGND _1600_/B _1598_/B _2630_/Q sky130_fd_sc_hd__and2_0
Xload_slew150 VPWR VGND load_slew150/X fanout149/X VPWR VGND sky130_fd_sc_hd__buf_4
X_2218_ VPWR VGND VGND VPWR _2220_/A _2219_/A _2220_/B sky130_fd_sc_hd__nand2_1
X_2149_ VPWR VGND VGND VPWR _2273_/A _2152_/B _2149_/B sky130_fd_sc_hd__nand2_1
XFILLER_14_23 VGND VPWR VPWR VGND sky130_fd_sc_hd__decap_4
X_1520_ VPWR VGND VPWR VGND _1519_/Y _1486_/D _1482_/Y _1521_/B sky130_fd_sc_hd__a21oi_1
X_1382_ VPWR VGND VGND VPWR _2283_/A _1382_/Y _2242_/B sky130_fd_sc_hd__nand2_1
X_1451_ VPWR VGND VGND VPWR _2485_/Q _1415_/Y _1451_/Y _1450_/Y _1449_/Y sky130_fd_sc_hd__o2bb2ai_1
X_2003_ VGND VPWR VPWR VGND _2583_/D _2408_/Q _2003_/S hold320/X sky130_fd_sc_hd__mux2_1
X_1718_ VPWR VGND VGND VPWR _2444_/Q _2386_/Q _2128_/B sky130_fd_sc_hd__nor2_1
X_1649_ VGND VPWR _2468_/Q _1650_/B _2470_/Q VPWR VGND sky130_fd_sc_hd__xnor2_1
XFILLER_41_43 VGND VPWR VPWR VGND sky130_fd_sc_hd__decap_4
XFILLER_64_227 VGND VPWR VPWR VGND sky130_fd_sc_hd__decap_12
XFILLER_56_3 VPWR VGND VPWR VGND sky130_fd_sc_hd__decap_6
X_2621_ VGND VPWR VPWR VGND _2633_/CLK _2621_/D fanout187/A _2621_/Q sky130_fd_sc_hd__dfrtp_1
X_1503_ VGND VPWR VPWR VGND _1469_/Y locked _2176_/A _1503_/Y _1502_/Y sky130_fd_sc_hd__a31oi_1
X_2552_ VGND VPWR VPWR VGND clkload9/A _2552_/D load_slew166/X _2552_/Q sky130_fd_sc_hd__dfrtp_1
X_2483_ VGND VPWR VPWR VGND clkload4/A _2483_/D fanout159/A _2483_/Q sky130_fd_sc_hd__dfrtp_1
X_1434_ VPWR VGND VGND VPWR _1435_/C _1434_/C _2474_/Q _1434_/B sky130_fd_sc_hd__maj3_1
X_1296_ VPWR VGND VGND VPWR _2476_/Q _1296_/Y _1296_/B sky130_fd_sc_hd__nand2_1
X_1365_ VPWR VGND VPWR VGND _1368_/B _2484_/Q _1356_/B _1365_/X _2318_/A sky130_fd_sc_hd__a22o_1
XFILLER_11_57 VPWR VGND VPWR VGND sky130_fd_sc_hd__decap_6
XFILLER_61_219 VGND VPWR VPWR VGND sky130_fd_sc_hd__decap_4
XFILLER_54_271 VPWR VGND VPWR VGND sky130_fd_sc_hd__decap_8
XFILLER_46_249 VPWR VGND VPWR VGND sky130_fd_sc_hd__decap_3
XPHY_EDGE_ROW_30_Left_101 VPWR VGND VPWR VGND sky130_fd_sc_hd__decap_3
X_2604_ VGND VPWR VPWR VGND clkload8/A _2604_/D wire181/X _2604_/Q sky130_fd_sc_hd__dfrtp_1
X_1983_ VGND VPWR VPWR VGND _2563_/D _2388_/Q _2034_/B hold297/X sky130_fd_sc_hd__mux2_1
X_2466_ VGND VPWR VPWR VGND _2633_/CLK _2466_/D wire181/X _2466_/Q sky130_fd_sc_hd__dfrtp_1
X_2535_ VGND VPWR VPWR VGND _2606_/CLK _2535_/D fanout183/A _2535_/Q sky130_fd_sc_hd__dfrtp_1
X_1417_ VGND VPWR VGND VPWR _1379_/Y _1445_/A _1418_/B _1417_/A2 sky130_fd_sc_hd__o21ai_0
X_1279_ VPWR VGND VGND VPWR _2185_/B _1430_/A _2423_/Q sky130_fd_sc_hd__nand2_1
X_2397_ VGND VPWR VPWR VGND clkload1/A _2397_/D load_slew144/X _2397_/Q sky130_fd_sc_hd__dfrtp_1
X_1348_ VPWR VGND VGND VPWR _2274_/A _1337_/Y _1347_/Y _2483_/Q _1348_/Y sky130_fd_sc_hd__o22ai_1
XFILLER_51_274 VPWR VGND VPWR VGND sky130_fd_sc_hd__decap_6
XFILLER_22_23 VGND VPWR VPWR VGND sky130_fd_sc_hd__decap_4
Xfanout140 VGND VPWR VGND VPWR _2423_/Q _2171_/A sky130_fd_sc_hd__clkdlybuf4s50_1
Xfanout173 VGND VPWR VGND VPWR fanout191/X fanout173/X sky130_fd_sc_hd__clkdlybuf4s50_1
Xfanout151 VGND VPWR VGND VPWR fanout156/X fanout151/X sky130_fd_sc_hd__clkdlybuf4s50_1
XFILLER_27_271 VPWR VGND VPWR VGND sky130_fd_sc_hd__decap_8
X_2251_ VPWR VGND VPWR VGND _2250_/X _2249_/Y _2297_/A _2251_/Y sky130_fd_sc_hd__a21oi_1
X_2320_ VPWR VGND VGND VPWR _2317_/X _2320_/Y _2306_/Y _2304_/Y _2318_/Y sky130_fd_sc_hd__o211ai_1
XFILLER_6_197 VPWR VGND VPWR VGND sky130_fd_sc_hd__decap_6
X_2182_ VGND VPWR VPWR VGND _1200_/Y _2424_/D _2254_/B2 _2136_/B _2180_/Y _2181_/Y
+ sky130_fd_sc_hd__a32oi_1
X_1202_ VPWR VGND VGND VPWR _2316_/B _1202_/Y sky130_fd_sc_hd__inv_1
XFILLER_19_3 VPWR VGND VPWR VGND sky130_fd_sc_hd__decap_3
X_1966_ VPWR VGND VGND VPWR _1966_/A _1966_/Y _1966_/B sky130_fd_sc_hd__nand2_1
X_1897_ VPWR VGND VGND VPWR _1897_/A _1897_/Y _1969_/B sky130_fd_sc_hd__nand2_1
X_2518_ VGND VPWR VPWR VGND _2592_/CLK _2518_/D fanout148/X _2518_/Q sky130_fd_sc_hd__dfrtp_1
X_2449_ VGND VPWR VPWR VGND clkload2/A _2449_/D fanout149/X _2449_/Q sky130_fd_sc_hd__dfrtp_1
XFILLER_66_108 VPWR VGND VPWR VGND sky130_fd_sc_hd__decap_8
X_1820_ VPWR VGND VGND VPWR _2508_/Q _1829_/B _1828_/B sky130_fd_sc_hd__nand2_1
XFILLER_30_222 VGND VPWR VPWR VGND sky130_fd_sc_hd__decap_4
X_1682_ VGND VPWR VGND VPWR _2201_/C _1680_/A _1683_/B _1680_/B sky130_fd_sc_hd__o21ai_0
X_1751_ VPWR VGND VGND VPWR _2461_/Q _2403_/Q _2119_/A sky130_fd_sc_hd__nor2_1
X_2234_ VPWR VGND VPWR VGND _2234_/B _2234_/C _2234_/A _2234_/X sky130_fd_sc_hd__or3_1
X_2303_ VPWR VGND VGND VPWR _2305_/B _2351_/B _2303_/Y sky130_fd_sc_hd__nor2_1
X_2165_ VGND VPWR VGND VPWR _2173_/A _2171_/A _2165_/Y _2255_/B sky130_fd_sc_hd__o21ai_0
X_2096_ VPWR VGND VGND VPWR _2096_/A _2096_/B _2114_/C _2096_/C sky130_fd_sc_hd__nand3_1
X_1949_ VGND VPWR VGND VPWR _1948_/Y _1948_/B _2549_/D _1947_/Y sky130_fd_sc_hd__o21ai_0
XFILLER_21_244 VGND VPWR VPWR VGND sky130_fd_sc_hd__decap_12
XFILLER_0_159 VPWR VGND VPWR VGND sky130_fd_sc_hd__decap_8
XPHY_EDGE_ROW_13_Right_13 VPWR VGND VPWR VGND sky130_fd_sc_hd__decap_3
X_1803_ VPWR VGND VGND VPWR _2499_/Q _2500_/Q _1806_/B _1805_/D sky130_fd_sc_hd__nand3_1
XPHY_EDGE_ROW_22_Right_22 VPWR VGND VPWR VGND sky130_fd_sc_hd__decap_3
XPHY_EDGE_ROW_68_Left_139 VPWR VGND VPWR VGND sky130_fd_sc_hd__decap_3
Xhold215 _2530_/D _1892_/Y VPWR VGND VGND VPWR sky130_fd_sc_hd__dlygate4sd3_1
Xhold248 _1840_/A _2513_/Q VPWR VGND VGND VPWR sky130_fd_sc_hd__dlygate4sd3_1
Xhold259 hold259/X _2577_/Q VPWR VGND VGND VPWR sky130_fd_sc_hd__dlygate4sd3_1
Xhold204 _1954_/A _2551_/Q VPWR VGND VGND VPWR sky130_fd_sc_hd__dlygate4sd3_1
X_1596_ VPWR VGND VGND VPWR _1596_/C _1598_/B _1603_/A _2629_/D sky130_fd_sc_hd__nor3_1
Xhold226 _2539_/D _1919_/Y VPWR VGND VGND VPWR sky130_fd_sc_hd__dlygate4sd3_1
XFILLER_7_281 VPWR VGND VPWR VGND sky130_fd_sc_hd__decap_8
Xhold237 _1942_/A _2547_/Q VPWR VGND VGND VPWR sky130_fd_sc_hd__dlygate4sd3_1
X_1734_ VPWR VGND VPWR VGND _2397_/Q _2455_/Q _1734_/Y _2456_/Q _2398_/Q sky130_fd_sc_hd__a22oi_1
X_1665_ VPWR VGND VGND VPWR _1690_/A _1692_/B _1690_/B sky130_fd_sc_hd__nand2_1
X_2217_ VGND VPWR VGND VPWR _2199_/Y _2198_/A _2220_/B _2137_/A sky130_fd_sc_hd__o21ai_0
Xload_slew184 VPWR VGND _2429_/SET_B fanout183/X VPWR VGND sky130_fd_sc_hd__buf_4
XFILLER_38_152 VGND VPWR VPWR VGND sky130_fd_sc_hd__decap_4
Xload_slew162 VPWR VGND load_slew162/X fanout161/X VPWR VGND sky130_fd_sc_hd__buf_4
XPHY_EDGE_ROW_31_Right_31 VPWR VGND VPWR VGND sky130_fd_sc_hd__decap_3
X_2079_ VPWR VGND VGND VPWR _2079_/Y _2101_/A _2080_/B _2080_/D _2409_/Q _2083_/B1
+ sky130_fd_sc_hd__o2111ai_1
X_2148_ VGND VPWR VGND VPWR _2147_/Y _2287_/B _2148_/Y _1692_/A sky130_fd_sc_hd__o21ai_0
XPHY_EDGE_ROW_40_Right_40 VPWR VGND VPWR VGND sky130_fd_sc_hd__decap_3
XFILLER_30_23 VGND VPWR VPWR VGND sky130_fd_sc_hd__decap_4
XFILLER_44_111 VPWR VGND VPWR VGND sky130_fd_sc_hd__decap_8
X_1450_ VPWR VGND VPWR VGND _2484_/Q _1416_/Y _1450_/Y _2485_/Q _1415_/Y sky130_fd_sc_hd__a22oi_1
X_1381_ VGND VPWR VGND VPWR _1381_/X _2272_/A _2287_/B _2283_/A _1486_/A sky130_fd_sc_hd__o211a_1
X_2002_ VGND VPWR VPWR VGND _2582_/D _2407_/Q _2003_/S hold298/X sky130_fd_sc_hd__mux2_1
X_1579_ VPWR VGND VPWR VGND _1578_/C _2622_/Q _2623_/Q _1580_/C sky130_fd_sc_hd__a21oi_1
X_1717_ VPWR VGND VGND VPWR _2445_/Q _2387_/Q _2128_/A sky130_fd_sc_hd__nor2_1
X_1648_ VPWR VGND VGND VPWR _2468_/Q _2470_/Q _1648_/Y sky130_fd_sc_hd__nor2b_1
XFILLER_41_169 VPWR VGND VPWR VGND sky130_fd_sc_hd__decap_6
XFILLER_1_265 VGND VPWR VPWR VGND sky130_fd_sc_hd__decap_12
XFILLER_64_239 VPWR VGND VPWR VGND sky130_fd_sc_hd__decap_3
XFILLER_17_122 VPWR VGND VPWR VGND sky130_fd_sc_hd__decap_3
X_2620_ VGND VPWR VPWR VGND _2633_/CLK _2620_/D fanout187/A _2620_/Q sky130_fd_sc_hd__dfrtp_1
X_1433_ VPWR VGND VGND VPWR _1434_/C _1433_/C _2473_/Q _1433_/B sky130_fd_sc_hd__maj3_1
X_1502_ VPWR VGND VGND VPWR _1523_/A _1502_/B _1502_/Y sky130_fd_sc_hd__nor2_1
X_2551_ VGND VPWR VPWR VGND clkload9/A _2551_/D load_slew168/X _2551_/Q sky130_fd_sc_hd__dfrtp_1
X_2482_ VGND VPWR VPWR VGND clkload4/A _2482_/D fanout159/A _2482_/Q sky130_fd_sc_hd__dfrtp_1
X_1295_ VGND VPWR VPWR VGND _1295_/A _1296_/B _1295_/B sky130_fd_sc_hd__xor2_1
X_1364_ VGND VPWR VPWR VGND _1371_/A _1368_/B _1364_/B sky130_fd_sc_hd__xor2_1
XFILLER_31_191 VGND VPWR VPWR VGND sky130_fd_sc_hd__decap_4
XFILLER_46_217 VPWR VGND VPWR VGND sky130_fd_sc_hd__decap_8
XFILLER_22_180 VGND VPWR VPWR VGND sky130_fd_sc_hd__decap_12
XFILLER_60_253 VPWR VGND VPWR VGND sky130_fd_sc_hd__decap_6
X_1982_ VGND VPWR VPWR VGND _1982_/X _2387_/Q _2010_/B hold300/X sky130_fd_sc_hd__mux2_1
X_2603_ VGND VPWR VPWR VGND clkload9/A _2603_/D fanout173/X _2603_/Q sky130_fd_sc_hd__dfrtp_1
X_2534_ VGND VPWR VPWR VGND _2606_/CLK _2534_/D _2429_/SET_B _2534_/Q sky130_fd_sc_hd__dfrtp_1
X_2465_ VGND VPWR VPWR VGND _2607_/CLK _2465_/D wire181/X _2465_/Q sky130_fd_sc_hd__dfrtp_1
X_2396_ VGND VPWR VPWR VGND clkload1/A _2396_/D load_slew150/X _2396_/Q sky130_fd_sc_hd__dfrtp_1
X_1416_ VGND VPWR _1416_/B _1416_/Y _1416_/A VPWR VGND sky130_fd_sc_hd__xnor2_1
X_1347_ VPWR VGND VGND VPWR _1357_/A _1347_/Y _1347_/B sky130_fd_sc_hd__nand2_1
X_1278_ VGND VPWR VGND VPWR _1277_/Y _1431_/B _1282_/B _2423_/Q sky130_fd_sc_hd__o21ai_0
Xwire43 VGND VPWR VPWR VGND wire43/A wire43/X sky130_fd_sc_hd__clkdlybuf4s25_1
Xwire32 VGND VPWR VPWR VGND wire32/A wire32/X sky130_fd_sc_hd__clkdlybuf4s25_1
XFILLER_28_239 VPWR VGND VPWR VGND sky130_fd_sc_hd__decap_3
Xfanout174 VGND VPWR VGND VPWR fanout182/X fanout174/X sky130_fd_sc_hd__clkdlybuf4s50_1
Xfanout130 VGND VPWR VGND VPWR _2230_/B _2201_/A sky130_fd_sc_hd__clkdlybuf4s50_1
Xfanout185 VGND VPWR VGND VPWR fanout191/X fanout185/X sky130_fd_sc_hd__clkdlybuf4s50_1
Xfanout141 VGND VPWR VGND VPWR fanout145/X fanout141/X sky130_fd_sc_hd__clkdlybuf4s50_1
Xfanout163 VGND VPWR VGND VPWR fanout192/X fanout163/X sky130_fd_sc_hd__clkdlybuf4s50_1
XPHY_EDGE_ROW_69_Right_69 VPWR VGND VPWR VGND sky130_fd_sc_hd__decap_3
XFILLER_42_220 VGND VPWR VPWR VGND sky130_fd_sc_hd__decap_12
XFILLER_6_132 VPWR VGND VPWR VGND sky130_fd_sc_hd__decap_8
X_1201_ VPWR VGND VGND VPWR _2171_/A _1201_/Y sky130_fd_sc_hd__inv_1
X_2250_ VGND VPWR VGND VPWR _2250_/X _2234_/X _2248_/X _2236_/A _2235_/A sky130_fd_sc_hd__a211o_1
X_2181_ VPWR VGND VPWR VGND _2175_/X _2173_/A _2254_/B2 _2181_/Y sky130_fd_sc_hd__a21oi_1
XPHY_EDGE_ROW_25_Left_96 VPWR VGND VPWR VGND sky130_fd_sc_hd__decap_3
X_1965_ VPWR VGND VGND VPWR _2554_/Q _1965_/Y _2580_/Q _1965_/S sky130_fd_sc_hd__mux2i_1
X_1896_ VPWR VGND VGND VPWR _2531_/Q _1896_/Y _2605_/Q _1902_/S sky130_fd_sc_hd__mux2i_1
X_2517_ VGND VPWR VPWR VGND clkload1/A _2517_/D load_slew150/X _2517_/Q sky130_fd_sc_hd__dfrtp_1
X_2379_ VPWR VGND VGND VPWR _2379_/A _2379_/Y _2445_/Q sky130_fd_sc_hd__nand2_1
X_2448_ VGND VPWR VPWR VGND clkload2/A _2448_/D fanout155/X _2448_/Q sky130_fd_sc_hd__dfrtp_1
XFILLER_17_57 VGND VPWR VPWR VGND sky130_fd_sc_hd__decap_4
X_1750_ VPWR VGND VPWR VGND _1749_/Y _2038_/B _1708_/Y _2487_/D sky130_fd_sc_hd__a21oi_1
X_1681_ VPWR VGND VPWR VGND _1680_/Y _1671_/Y _2136_/A _2475_/D sky130_fd_sc_hd__a21oi_1
X_2233_ VPWR VGND VGND VPWR _2234_/A _2234_/B _2234_/C _2235_/A sky130_fd_sc_hd__o21a_1
XFILLER_31_3 VGND VPWR VPWR VGND sky130_fd_sc_hd__decap_4
X_2302_ VPWR VGND VPWR VGND _2359_/S _2259_/A _2301_/Y _2302_/Y sky130_fd_sc_hd__a21oi_1
X_2164_ VGND VPWR VPWR VGND wire37/X _2159_/Y _2153_/Y _2164_/Y _2163_/Y sky130_fd_sc_hd__a31oi_1
X_2095_ VGND VPWR _2108_/B _2096_/B _2096_/A _2096_/C VPWR VGND sky130_fd_sc_hd__and3_1
XFILLER_21_212 VGND VPWR VPWR VGND sky130_fd_sc_hd__decap_4
X_1879_ VPWR VGND VGND VPWR _1879_/A _1879_/Y _1951_/B sky130_fd_sc_hd__nand2_1
X_1948_ VPWR VGND VGND VPWR _1948_/A _1948_/Y _1948_/B sky130_fd_sc_hd__nand2_1
XFILLER_21_256 VGND VPWR VPWR VGND sky130_fd_sc_hd__decap_4
XFILLER_0_149 VPWR VGND VPWR VGND sky130_fd_sc_hd__decap_6
XFILLER_56_197 VGND VPWR VPWR VGND sky130_fd_sc_hd__decap_12
XFILLER_69_96 VPWR VGND VPWR VGND sky130_fd_sc_hd__decap_3
X_1802_ VGND VPWR _1805_/D _2499_/D _1812_/A VPWR VGND sky130_fd_sc_hd__xnor2_1
X_1733_ VPWR VGND VGND VPWR _2452_/Q _2394_/Q _2125_/B sky130_fd_sc_hd__nor2_1
X_1664_ VPWR VGND VGND VPWR _1688_/A _1688_/B _1690_/B sky130_fd_sc_hd__nor2_1
X_1595_ VPWR VGND VPWR VGND _1594_/C _2628_/Q _2629_/Q _1596_/C sky130_fd_sc_hd__a21oi_1
Xhold249 _1912_/A _2537_/Q VPWR VGND VGND VPWR sky130_fd_sc_hd__dlygate4sd3_1
Xhold216 _1867_/A _2522_/Q VPWR VGND VGND VPWR sky130_fd_sc_hd__dlygate4sd3_1
Xhold238 _1864_/A _2521_/Q VPWR VGND VGND VPWR sky130_fd_sc_hd__dlygate4sd3_1
Xhold227 _1924_/A _2541_/Q VPWR VGND VGND VPWR sky130_fd_sc_hd__dlygate4sd3_1
Xhold205 _1921_/A _2540_/Q VPWR VGND VGND VPWR sky130_fd_sc_hd__dlygate4sd3_1
X_2216_ VPWR VGND VGND VPWR _2216_/A _2234_/B _2220_/A sky130_fd_sc_hd__nor2_1
X_2147_ VPWR VGND VGND VPWR _2272_/B _1690_/A _2145_/Y _2146_/Y _2147_/Y sky130_fd_sc_hd__o22ai_1
XFILLER_38_197 VPWR VGND VPWR VGND sky130_fd_sc_hd__decap_8
Xload_slew152 VPWR VGND load_slew152/X fanout151/X VPWR VGND sky130_fd_sc_hd__buf_4
X_2078_ VPWR VGND VGND VPWR _2101_/A _2078_/Y _2080_/D _2083_/B1 _2080_/B sky130_fd_sc_hd__o211ai_1
XPHY_EDGE_ROW_12_Left_83 VPWR VGND VPWR VGND sky130_fd_sc_hd__decap_3
XFILLER_44_178 VGND VPWR VPWR VGND sky130_fd_sc_hd__decap_12
XFILLER_4_263 VGND VPWR VPWR VGND sky130_fd_sc_hd__decap_12
XFILLER_4_241 VPWR VGND VPWR VGND sky130_fd_sc_hd__decap_8
X_1380_ VGND VPWR _2257_/A _1445_/A _2435_/Q VPWR VGND sky130_fd_sc_hd__xnor2_1
XFILLER_67_237 VGND VPWR VPWR VGND sky130_fd_sc_hd__decap_4
X_2001_ VGND VPWR VPWR VGND _2581_/D _2406_/Q _2003_/S hold277/X sky130_fd_sc_hd__mux2_1
X_1716_ VPWR VGND VPWR VGND _2385_/Q _2443_/Q _1716_/Y _2444_/Q _2386_/Q sky130_fd_sc_hd__a22oi_1
X_1578_ VGND VPWR _1584_/C _2622_/Q _2623_/Q _1578_/C VPWR VGND sky130_fd_sc_hd__and3_1
X_1647_ VPWR VGND VPWR VGND _1646_/Y hold381/X _1464_/C _2467_/D _1464_/B sky130_fd_sc_hd__a22o_1
XFILLER_26_167 VPWR VGND VPWR VGND sky130_fd_sc_hd__decap_8
XFILLER_9_3 VPWR VGND VPWR VGND sky130_fd_sc_hd__decap_8
XFILLER_57_281 VPWR VGND VPWR VGND sky130_fd_sc_hd__decap_8
XFILLER_49_237 VPWR VGND VPWR VGND sky130_fd_sc_hd__decap_3
XFILLER_1_277 VPWR VGND VPWR VGND sky130_fd_sc_hd__decap_3
X_2550_ VGND VPWR VPWR VGND clkload9/A _2550_/D load_slew168/X _2550_/Q sky130_fd_sc_hd__dfrtp_1
X_1432_ VPWR VGND VGND VPWR _1433_/C _1432_/C _2472_/Q _1432_/B sky130_fd_sc_hd__maj3_1
X_1501_ VPWR VGND VPWR VGND _1523_/A _1573_/C _1504_/C _1500_/Y sky130_fd_sc_hd__o21bai_1
X_1363_ VPWR VGND VPWR VGND _2331_/B _1202_/Y _1362_/Y _1363_/Y sky130_fd_sc_hd__a21oi_1
X_2481_ VGND VPWR VPWR VGND clkload4/A _2481_/D fanout159/X _2481_/Q sky130_fd_sc_hd__dfrtp_1
X_1294_ VGND VPWR VPWR VGND _1289_/C _1289_/B _1289_/A _1295_/B _1287_/B sky130_fd_sc_hd__a31oi_1
XFILLER_23_137 VPWR VGND VPWR VGND sky130_fd_sc_hd__decap_3
XFILLER_23_148 VGND VPWR VPWR VGND sky130_fd_sc_hd__decap_12
XFILLER_11_37 VPWR VGND VPWR VGND sky130_fd_sc_hd__decap_8
XFILLER_54_262 VGND VPWR VPWR VGND sky130_fd_sc_hd__decap_4
XFILLER_52_88 VGND VPWR VPWR VGND sky130_fd_sc_hd__decap_4
XFILLER_22_192 VGND VPWR VPWR VGND sky130_fd_sc_hd__decap_4
X_1981_ VGND VPWR VPWR VGND _1981_/X _2386_/Q _2010_/B hold289/X sky130_fd_sc_hd__mux2_1
X_2533_ VGND VPWR VPWR VGND _2606_/CLK _2533_/D wire181/X _2533_/Q sky130_fd_sc_hd__dfrtp_1
X_2602_ VGND VPWR VPWR VGND clkload9/A _2602_/D load_slew166/X _2602_/Q sky130_fd_sc_hd__dfrtp_1
X_2464_ VGND VPWR VPWR VGND _2606_/CLK _2464_/D wire181/X _2464_/Q sky130_fd_sc_hd__dfrtp_1
X_2395_ VGND VPWR VPWR VGND clkload1/A _2395_/D load_slew144/X _2395_/Q sky130_fd_sc_hd__dfrtp_1
X_1415_ VGND VPWR _1415_/B _1415_/Y _1415_/A VPWR VGND sky130_fd_sc_hd__xnor2_1
X_1346_ VPWR VGND VGND VPWR _1347_/B _1343_/X _1485_/B _1341_/Y _1342_/Y _1340_/Y
+ sky130_fd_sc_hd__o2111ai_1
X_1277_ VPWR VGND VPWR VGND _2171_/A _2187_/B _2471_/Q _1277_/Y sky130_fd_sc_hd__a21oi_1
Xfanout131 VGND VPWR VGND VPWR _2428_/Q _2230_/B sky130_fd_sc_hd__clkdlybuf4s50_1
Xfanout120 VGND VPWR VGND VPWR _2305_/B _2257_/A sky130_fd_sc_hd__clkdlybuf4s50_1
Xfanout153 VGND VPWR VGND VPWR fanout156/X fanout153/X sky130_fd_sc_hd__clkdlybuf4s50_1
XFILLER_42_232 VGND VPWR VPWR VGND sky130_fd_sc_hd__decap_4
X_1200_ VPWR VGND VGND VPWR _2187_/B _1200_/Y sky130_fd_sc_hd__inv_1
X_2180_ VGND VPWR VGND VPWR _2179_/Y _2187_/B _2180_/Y _2283_/B sky130_fd_sc_hd__o21ai_0
XPHY_EDGE_ROW_0_Left_71 VPWR VGND VPWR VGND sky130_fd_sc_hd__decap_3
XFILLER_33_254 VGND VPWR VPWR VGND sky130_fd_sc_hd__decap_4
X_1964_ VGND VPWR VGND VPWR _1963_/Y _1966_/B _1964_/Y _1962_/Y sky130_fd_sc_hd__o21ai_0
X_1895_ VGND VPWR VGND VPWR _1894_/Y _1969_/B _2531_/D _1893_/Y sky130_fd_sc_hd__o21ai_0
Xclkbuf_leaf_13_clk VGND VPWR VGND VPWR clkbuf_leaf_9_clk/A clkload6/A sky130_fd_sc_hd__clkbuf_16
X_2447_ VGND VPWR VPWR VGND clkload2/A _2447_/D fanout155/X _2447_/Q sky130_fd_sc_hd__dfrtp_1
X_2516_ VGND VPWR VPWR VGND clkload2/A _2516_/D load_slew150/X _2516_/Q sky130_fd_sc_hd__dfrtp_1
X_2378_ VPWR VGND VGND VPWR _1241_/Y _2443_/D _2377_/Y _2380_/S sky130_fd_sc_hd__mux2i_1
X_1329_ VPWR VGND VGND VPWR _1519_/A _1329_/B _1341_/A sky130_fd_sc_hd__nor2_1
XFILLER_17_69 VPWR VGND VPWR VGND sky130_fd_sc_hd__decap_8
XFILLER_59_140 VPWR VGND VPWR VGND sky130_fd_sc_hd__decap_3
XFILLER_58_54 VGND VPWR VPWR VGND sky130_fd_sc_hd__decap_12
X_1680_ VGND VPWR _1680_/B _1680_/Y _1680_/A VPWR VGND sky130_fd_sc_hd__xnor2_1
X_2301_ VGND VPWR VGND VPWR _1557_/A _2305_/B _2301_/Y _2359_/S sky130_fd_sc_hd__o21ai_0
Xclkbuf_leaf_2_clk VGND VPWR VGND VPWR clkload0/A clkload8/A sky130_fd_sc_hd__clkbuf_16
X_2232_ VGND VPWR _2232_/B _2234_/C _2232_/A VPWR VGND sky130_fd_sc_hd__xnor2_1
X_2163_ VGND VPWR VGND VPWR _2168_/B _2156_/Y _2163_/Y _2162_/Y sky130_fd_sc_hd__o21ai_0
XFILLER_24_3 VPWR VGND VPWR VGND sky130_fd_sc_hd__decap_8
X_2094_ VPWR VGND VPWR VGND _1557_/A _2092_/Y _2096_/C _2082_/A _2167_/A sky130_fd_sc_hd__a22oi_1
X_1878_ VPWR VGND VGND VPWR _2525_/Q _1878_/Y _2599_/Q _1884_/S sky130_fd_sc_hd__mux2i_1
X_1947_ VPWR VGND VGND VPWR _2548_/Q _1947_/Y _2574_/Q _1947_/S sky130_fd_sc_hd__mux2i_1
XFILLER_56_176 VPWR VGND VPWR VGND sky130_fd_sc_hd__decap_6
XFILLER_12_257 VPWR VGND VPWR VGND sky130_fd_sc_hd__decap_8
XFILLER_47_165 VPWR VGND VPWR VGND sky130_fd_sc_hd__decap_3
X_1801_ VPWR VGND VGND VPWR _2499_/Q _1804_/B _1805_/D sky130_fd_sc_hd__nand2_1
Xwire181 VGND VPWR wire181/A wire181/X VPWR VGND sky130_fd_sc_hd__clkbuf_4
X_1663_ VPWR VGND VGND VPWR _2477_/Q _2476_/Q _1688_/B _1663_/C sky130_fd_sc_hd__nand3_1
Xhold217 _1837_/A _2512_/Q VPWR VGND VGND VPWR sky130_fd_sc_hd__dlygate4sd3_1
X_1732_ VPWR VGND VGND VPWR _2454_/Q _2396_/Q _2126_/D sky130_fd_sc_hd__nor2_1
Xhold206 _2540_/D _1922_/Y VPWR VGND VGND VPWR sky130_fd_sc_hd__dlygate4sd3_1
Xhold228 _1963_/A _2554_/Q VPWR VGND VGND VPWR sky130_fd_sc_hd__dlygate4sd3_1
Xhold239 _1957_/A _2552_/Q VPWR VGND VGND VPWR sky130_fd_sc_hd__dlygate4sd3_1
X_1594_ VGND VPWR _1598_/B _2628_/Q _2629_/Q _1594_/C VPWR VGND sky130_fd_sc_hd__and3_1
XPHY_EDGE_ROW_7_Right_7 VPWR VGND VPWR VGND sky130_fd_sc_hd__decap_3
Xload_slew142 VGND VPWR fanout141/X load_slew142/X VPWR VGND sky130_fd_sc_hd__clkbuf_4
Xload_slew164 VPWR VGND fanout159/A fanout163/X VPWR VGND sky130_fd_sc_hd__buf_4
Xload_slew175 VGND VPWR fanout174/X load_slew175/X VPWR VGND sky130_fd_sc_hd__clkbuf_4
XFILLER_53_113 VPWR VGND VPWR VGND sky130_fd_sc_hd__decap_3
Xload_slew186 VPWR VGND fanout183/A fanout185/X VPWR VGND sky130_fd_sc_hd__buf_2
X_2215_ VGND VPWR VPWR VGND _2234_/B _2215_/B _2478_/Q sky130_fd_sc_hd__and2_0
X_2146_ VPWR VGND VGND VPWR _2283_/A _2232_/A _1688_/A _2257_/B _2146_/Y sky130_fd_sc_hd__o22ai_1
X_2077_ VPWR VGND VGND VPWR _2082_/A _2080_/D _2077_/B sky130_fd_sc_hd__nand2_1
XFILLER_4_275 VGND VPWR VPWR VGND sky130_fd_sc_hd__decap_12
X_2000_ VGND VPWR VPWR VGND _2000_/X _2405_/Q _2000_/S hold283/X sky130_fd_sc_hd__mux2_1
XFILLER_35_113 VPWR VGND VPWR VGND sky130_fd_sc_hd__decap_6
X_1715_ VPWR VGND VGND VPWR _2447_/Q _1715_/Y _2389_/Q sky130_fd_sc_hd__nand2_1
XFILLER_6_93 VPWR VGND VPWR VGND sky130_fd_sc_hd__decap_3
X_1646_ VGND VPWR VGND VPWR _1657_/D _2077_/B _1646_/Y _1657_/C sky130_fd_sc_hd__o21ai_0
X_1577_ VPWR VGND VGND VPWR _1977_/B _1577_/B _2622_/D sky130_fd_sc_hd__nor2_1
X_2129_ VPWR VGND VGND VPWR _2129_/C _2129_/B _2129_/A _2130_/D sky130_fd_sc_hd__nor3_1
XFILLER_41_57 VPWR VGND VPWR VGND sky130_fd_sc_hd__decap_6
XFILLER_17_135 VPWR VGND VPWR VGND sky130_fd_sc_hd__decap_6
X_1500_ VPWR VGND VGND VPWR _1500_/A _1500_/B _1500_/Y sky130_fd_sc_hd__nor2_1
X_2480_ VGND VPWR VPWR VGND clkload3/A _2480_/D fanout159/A _2480_/Q sky130_fd_sc_hd__dfrtp_1
X_1431_ VPWR VGND VGND VPWR _2471_/Q _1431_/B _1432_/C sky130_fd_sc_hd__nand2b_1
X_1293_ VGND VPWR VPWR VGND _2242_/B _1295_/A _2201_/A sky130_fd_sc_hd__xor2_1
X_1362_ VPWR VGND VGND VPWR _1364_/B _1371_/A _1362_/Y sky130_fd_sc_hd__nor2b_1
X_1629_ VPWR VGND VGND VPWR _2383_/A _1629_/Y _2459_/Q sky130_fd_sc_hd__nand2_1
XFILLER_36_46 VPWR VGND VPWR VGND sky130_fd_sc_hd__decap_3
XFILLER_45_252 VGND VPWR VPWR VGND sky130_fd_sc_hd__decap_4
X_1980_ VPWR VGND VGND VPWR _1980_/A _2130_/A _1980_/Y sky130_fd_sc_hd__nor2_1
XFILLER_9_164 VGND VPWR VPWR VGND sky130_fd_sc_hd__decap_4
X_2532_ VGND VPWR VPWR VGND _2606_/CLK _2532_/D load_slew170/X _2532_/Q sky130_fd_sc_hd__dfrtp_1
X_2463_ VGND VPWR VPWR VGND _2606_/CLK _2463_/D load_slew177/X _2463_/Q sky130_fd_sc_hd__dfrtp_1
X_2601_ VGND VPWR VPWR VGND clkload9/A _2601_/D load_slew166/X _2601_/Q sky130_fd_sc_hd__dfrtp_1
X_1276_ VPWR VGND VGND VPWR _2187_/B _2171_/A _1495_/B sky130_fd_sc_hd__nor2_1
X_2394_ VGND VPWR VPWR VGND clkload6/A _2394_/D fanout143/X _2394_/Q sky130_fd_sc_hd__dfrtp_1
X_1414_ VPWR VGND VGND VPWR _2332_/A _1414_/Y _1414_/B sky130_fd_sc_hd__nand2_1
X_1345_ VGND VPWR VGND VPWR _1485_/B _1343_/X _1340_/Y _1341_/Y _1342_/Y _1357_/A
+ sky130_fd_sc_hd__a311o_1
XFILLER_51_233 VGND VPWR VPWR VGND sky130_fd_sc_hd__decap_12
XFILLER_36_274 VPWR VGND VPWR VGND sky130_fd_sc_hd__decap_8
XFILLER_11_108 VGND VPWR VPWR VGND sky130_fd_sc_hd__decap_4
Xfanout132 VGND VPWR VGND VPWR _2427_/Q _2176_/A sky130_fd_sc_hd__clkdlybuf4s50_1
Xfanout165 VGND VPWR VGND VPWR fanout173/X fanout165/X sky130_fd_sc_hd__clkdlybuf4s50_1
Xfanout121 VGND VPWR VGND VPWR _2433_/Q _2305_/B sky130_fd_sc_hd__clkdlybuf4s50_1
Xfanout143 VGND VPWR VGND VPWR fanout145/X fanout143/X sky130_fd_sc_hd__clkdlybuf4s50_1
Xfanout110 VGND VPWR VGND VPWR _2316_/B _2158_/B sky130_fd_sc_hd__clkdlybuf4s50_1
Xfanout187 VGND VPWR VGND VPWR fanout187/A fanout187/X sky130_fd_sc_hd__clkdlybuf4s50_1
Xfanout176 VGND VPWR VGND VPWR fanout182/X fanout176/X sky130_fd_sc_hd__clkdlybuf4s50_1
XFILLER_42_244 VPWR VGND VPWR VGND sky130_fd_sc_hd__decap_8
XFILLER_33_266 VPWR VGND VPWR VGND sky130_fd_sc_hd__decap_6
XFILLER_33_244 VPWR VGND VPWR VGND sky130_fd_sc_hd__decap_3
X_1963_ VPWR VGND VGND VPWR _1963_/A _1963_/Y _1966_/B sky130_fd_sc_hd__nand2_1
X_1894_ VPWR VGND VGND VPWR _1894_/A _1894_/Y _1969_/B sky130_fd_sc_hd__nand2_1
X_2446_ VGND VPWR VPWR VGND clkload8/A _2446_/D load_slew172/X _2446_/Q sky130_fd_sc_hd__dfrtp_1
X_2515_ VGND VPWR VPWR VGND clkload2/A _2515_/D fanout151/X _2515_/Q sky130_fd_sc_hd__dfrtp_1
X_1259_ VPWR VGND VGND VPWR _1259_/A _1259_/Y sky130_fd_sc_hd__inv_1
X_2377_ VPWR VGND VGND VPWR _2379_/A _2377_/Y _2444_/Q sky130_fd_sc_hd__nand2_1
X_1328_ VPWR VGND VGND VPWR _1486_/A _2230_/A _1329_/B sky130_fd_sc_hd__nor2_1
XFILLER_58_66 VPWR VGND VPWR VGND sky130_fd_sc_hd__decap_3
XFILLER_15_200 VGND VPWR VPWR VGND sky130_fd_sc_hd__decap_4
X_2231_ VPWR VGND VGND VPWR _2479_/Q _2231_/Y _2232_/B sky130_fd_sc_hd__nand2_1
X_2300_ VPWR VGND VGND VPWR _2432_/D _2299_/Y fanout3/X _1466_/B _1519_/A sky130_fd_sc_hd__a2bb2oi_1
XFILLER_65_177 VPWR VGND VPWR VGND sky130_fd_sc_hd__decap_8
X_2093_ VGND VPWR VGND VPWR _1565_/Y _2082_/A _2096_/B _2360_/A sky130_fd_sc_hd__o21ai_0
X_2162_ VGND VPWR VPWR VGND _2159_/Y _2158_/Y _2157_/Y _2162_/Y _2155_/Y sky130_fd_sc_hd__a31oi_1
X_1877_ VGND VPWR VGND VPWR _1876_/Y _1951_/B _2525_/D hold377/X sky130_fd_sc_hd__o21ai_0
X_1946_ VGND VPWR VGND VPWR _1945_/Y _1945_/B _1946_/Y _1944_/Y sky130_fd_sc_hd__o21ai_0
XFILLER_56_100 VGND VPWR VPWR VGND sky130_fd_sc_hd__decap_4
X_2429_ VPWR VGND VPWR VGND _2429_/Q _2429_/SET_B _2429_/D clkload3/A sky130_fd_sc_hd__dfstp_2
XFILLER_56_188 VPWR VGND VPWR VGND sky130_fd_sc_hd__decap_8
XFILLER_12_247 VGND VPWR VPWR VGND sky130_fd_sc_hd__decap_4
X_1800_ VPWR VGND VGND VPWR _1805_/D _1800_/B _2498_/D sky130_fd_sc_hd__nor2_1
Xhold229 _2554_/D _1964_/Y VPWR VGND VGND VPWR sky130_fd_sc_hd__dlygate4sd3_1
Xhold207 _1900_/A _2533_/Q VPWR VGND VGND VPWR sky130_fd_sc_hd__dlygate4sd3_1
X_1662_ VPWR VGND VGND VPWR _2476_/Q _1685_/B _1663_/C sky130_fd_sc_hd__nand2_1
Xhold218 _1927_/A _2542_/Q VPWR VGND VGND VPWR sky130_fd_sc_hd__dlygate4sd3_1
XFILLER_7_251 VPWR VGND VPWR VGND sky130_fd_sc_hd__decap_3
X_1731_ VPWR VGND VGND VPWR _2453_/Q _2395_/Q _2126_/C sky130_fd_sc_hd__nor2_1
X_2214_ VPWR VGND VGND VPWR _2478_/Q _2215_/B _2216_/A sky130_fd_sc_hd__nor2_1
X_1593_ VPWR VGND VGND VPWR _1603_/A _1593_/B _2628_/D sky130_fd_sc_hd__nor2_1
XPHY_EDGE_ROW_37_Left_108 VPWR VGND VPWR VGND sky130_fd_sc_hd__decap_3
Xload_slew154 VPWR VGND load_slew154/X fanout153/X VPWR VGND sky130_fd_sc_hd__buf_4
X_2076_ VGND VPWR VPWR VGND _2408_/D _2408_/Q _2076_/S _2466_/Q sky130_fd_sc_hd__mux2_1
XFILLER_53_169 VGND VPWR VPWR VGND sky130_fd_sc_hd__decap_12
X_2145_ VGND VPWR VPWR VGND _2145_/Y _2200_/A _2144_/Y _2257_/B _1688_/A _2198_/A
+ sky130_fd_sc_hd__a221oi_1
XPHY_EDGE_ROW_46_Left_117 VPWR VGND VPWR VGND sky130_fd_sc_hd__decap_3
X_1929_ VPWR VGND VGND VPWR _2542_/Q _1929_/Y _2568_/Q _1932_/S sky130_fd_sc_hd__mux2i_1
XFILLER_14_38 VPWR VGND VPWR VGND sky130_fd_sc_hd__decap_6
XPHY_EDGE_ROW_55_Left_126 VPWR VGND VPWR VGND sky130_fd_sc_hd__decap_3
XPHY_EDGE_ROW_64_Left_135 VPWR VGND VPWR VGND sky130_fd_sc_hd__decap_3
XFILLER_4_221 VPWR VGND VPWR VGND sky130_fd_sc_hd__decap_3
XFILLER_35_169 VPWR VGND VPWR VGND sky130_fd_sc_hd__decap_8
X_1645_ VPWR VGND VGND VPWR _1247_/Y _2466_/D _1558_/Y _2380_/S sky130_fd_sc_hd__mux2i_1
X_1576_ VGND VPWR _1578_/C _1577_/B _2622_/Q VPWR VGND sky130_fd_sc_hd__xnor2_1
X_1714_ VPWR VGND VPWR VGND _2453_/Q _2454_/Q _2396_/Q _1743_/A _2395_/Q sky130_fd_sc_hd__a22o_1
X_2128_ VPWR VGND VGND VPWR _2128_/A _2128_/B _2129_/C _2128_/C sky130_fd_sc_hd__nand3_1
X_2059_ VGND VPWR VPWR VGND _2391_/D hold361/X _2060_/S _2449_/Q sky130_fd_sc_hd__mux2_1
XFILLER_66_11 VPWR VGND VPWR VGND sky130_fd_sc_hd__decap_3
X_1430_ VGND VPWR _1430_/B _1433_/B _1430_/A VPWR VGND sky130_fd_sc_hd__xnor2_1
X_1292_ VPWR VGND VPWR VGND _1284_/Y _1283_/Y _1291_/Y _1292_/X sky130_fd_sc_hd__a21o_1
X_1361_ VGND VPWR VPWR VGND _2158_/B _1364_/B _2331_/B sky130_fd_sc_hd__xor2_1
X_1559_ VPWR VGND VGND VPWR _2167_/A _1466_/B _1540_/X _1559_/Y _1454_/X _1558_/Y
+ sky130_fd_sc_hd__o32ai_1
X_1628_ VPWR VGND VGND VPWR _1227_/Y _2457_/D _1627_/Y _1628_/S sky130_fd_sc_hd__mux2i_1
XFILLER_54_253 VPWR VGND VPWR VGND sky130_fd_sc_hd__decap_6
XFILLER_39_261 VGND VPWR VPWR VGND sky130_fd_sc_hd__decap_4
XFILLER_39_250 VGND VPWR VPWR VGND sky130_fd_sc_hd__decap_4
XFILLER_60_234 VPWR VGND VPWR VGND sky130_fd_sc_hd__decap_6
X_2600_ VGND VPWR VPWR VGND clkload9/A _2600_/D load_slew168/X _2600_/Q sky130_fd_sc_hd__dfrtp_1
XFILLER_9_187 VGND VPWR VPWR VGND sky130_fd_sc_hd__decap_12
X_2462_ VGND VPWR VPWR VGND clkload9/A _2462_/D load_slew166/X _2462_/Q sky130_fd_sc_hd__dfrtp_1
X_2531_ VGND VPWR VPWR VGND _2606_/CLK _2531_/D load_slew170/X _2531_/Q sky130_fd_sc_hd__dfrtp_1
X_2393_ VGND VPWR VPWR VGND clkload6/A _2393_/D fanout148/X _2393_/Q sky130_fd_sc_hd__dfrtp_1
X_1413_ VPWR VGND VGND VPWR _1413_/C _1413_/B _2158_/B _1414_/B sky130_fd_sc_hd__nor3_1
X_1275_ VGND VPWR _1275_/B _1275_/Y _1275_/A VPWR VGND sky130_fd_sc_hd__xnor2_1
X_1344_ VPWR VGND VGND VPWR _2159_/A _1484_/A _1485_/B sky130_fd_sc_hd__nor2_1
XFILLER_28_209 VGND VPWR VPWR VGND sky130_fd_sc_hd__decap_12
Xfanout188 VGND VPWR VGND VPWR fanout190/X fanout188/X sky130_fd_sc_hd__clkdlybuf4s50_1
Xfanout133 VGND VPWR VGND VPWR _2427_/Q _2213_/B sky130_fd_sc_hd__clkdlybuf4s50_1
Xfanout155 VGND VPWR VGND VPWR fanout156/X fanout155/X sky130_fd_sc_hd__clkdlybuf4s50_1
Xfanout111 VGND VPWR VGND VPWR _2437_/Q _2316_/B sky130_fd_sc_hd__clkdlybuf4s50_1
Xfanout100 VGND VPWR VGND VPWR _2365_/B1 _1557_/A sky130_fd_sc_hd__clkdlybuf4s50_1
Xfanout122 VGND VPWR VGND VPWR _2432_/Q _2287_/B sky130_fd_sc_hd__clkdlybuf4s50_1
XPHY_EDGE_ROW_29_Right_29 VPWR VGND VPWR VGND sky130_fd_sc_hd__decap_3
XFILLER_27_220 VGND VPWR VPWR VGND sky130_fd_sc_hd__decap_4
XPHY_EDGE_ROW_38_Right_38 VPWR VGND VPWR VGND sky130_fd_sc_hd__decap_3
XPHY_EDGE_ROW_47_Right_47 VPWR VGND VPWR VGND sky130_fd_sc_hd__decap_3
XFILLER_18_220 VGND VPWR VPWR VGND sky130_fd_sc_hd__decap_12
X_1962_ VPWR VGND VGND VPWR _1960_/A _1962_/Y _2579_/Q _1965_/S sky130_fd_sc_hd__mux2i_1
XPHY_EDGE_ROW_56_Right_56 VPWR VGND VPWR VGND sky130_fd_sc_hd__decap_3
X_1893_ VPWR VGND VGND VPWR _1891_/A _1893_/Y hold375/X _1902_/S sky130_fd_sc_hd__mux2i_1
XPHY_EDGE_ROW_65_Right_65 VPWR VGND VPWR VGND sky130_fd_sc_hd__decap_3
X_2445_ VGND VPWR VPWR VGND clkload8/A _2445_/D fanout169/X _2445_/Q sky130_fd_sc_hd__dfrtp_1
X_2514_ VGND VPWR VPWR VGND clkload8/A _2514_/D fanout167/X _2514_/Q sky130_fd_sc_hd__dfrtp_1
XFILLER_5_190 VGND VPWR VPWR VGND sky130_fd_sc_hd__decap_12
X_2376_ VGND VPWR VGND VPWR _2375_/Y _1221_/Y _2442_/D _2375_/C sky130_fd_sc_hd__o21ai_0
X_1327_ VPWR VGND VGND VPWR _1339_/A _1331_/A _1339_/B sky130_fd_sc_hd__nand2_1
X_1258_ VPWR VGND VGND VPWR _2418_/Q _1550_/A sky130_fd_sc_hd__inv_1
XFILLER_24_212 VPWR VGND VPWR VGND sky130_fd_sc_hd__decap_8
XFILLER_3_149 VPWR VGND VPWR VGND sky130_fd_sc_hd__decap_3
XFILLER_58_23 VGND VPWR VPWR VGND sky130_fd_sc_hd__decap_4
X_2230_ VGND VPWR _2230_/B _2232_/B _2230_/A VPWR VGND sky130_fd_sc_hd__xnor2_1
XFILLER_0_85 VGND VPWR VPWR VGND sky130_fd_sc_hd__decap_12
X_2092_ VPWR VGND VGND VPWR _1560_/B _2168_/B _2092_/Y sky130_fd_sc_hd__nand2b_1
X_2161_ VGND VPWR VPWR VGND _2160_/Y _2157_/Y _2289_/A _2331_/A _2155_/Y wire37/A
+ sky130_fd_sc_hd__a2111oi_0
X_1945_ VPWR VGND VGND VPWR _1945_/A _1945_/Y _1945_/B sky130_fd_sc_hd__nand2_1
X_1876_ VPWR VGND VGND VPWR _1876_/A _1876_/Y _1951_/B sky130_fd_sc_hd__nand2_1
X_2428_ VPWR VGND VPWR VGND _2428_/Q fanout183/X _2428_/D clkload3/A sky130_fd_sc_hd__dfstp_2
X_2359_ VPWR VGND VGND VPWR _2316_/B _2360_/B _2318_/A _2359_/S sky130_fd_sc_hd__mux2i_1
Xhold208 _2533_/D _1901_/Y VPWR VGND VGND VPWR sky130_fd_sc_hd__dlygate4sd3_1
X_1661_ VPWR VGND VGND VPWR _1680_/A _1680_/B _1663_/C sky130_fd_sc_hd__nor2_1
X_1592_ VGND VPWR _1594_/C _1593_/B _2628_/Q VPWR VGND sky130_fd_sc_hd__xnor2_1
Xhold219 _1915_/A _2538_/Q VPWR VGND VGND VPWR sky130_fd_sc_hd__dlygate4sd3_1
XFILLER_11_281 VPWR VGND VPWR VGND sky130_fd_sc_hd__decap_8
X_1730_ _1730_/X _1726_/Y _2126_/A _2126_/B _1729_/Y VPWR VGND VGND VPWR sky130_fd_sc_hd__o31a_1
Xload_slew177 VPWR VGND load_slew177/X fanout176/X VPWR VGND sky130_fd_sc_hd__buf_4
X_2144_ VGND VPWR VPWR VGND _1303_/A _2476_/Q _2142_/Y _2477_/Q _2241_/B _2144_/Y
+ _2143_/Y sky130_fd_sc_hd__a222oi_1
X_2213_ VGND VPWR _2213_/B _2215_/B _2430_/Q VPWR VGND sky130_fd_sc_hd__xnor2_1
Xload_slew166 VGND VPWR fanout165/X load_slew166/X VPWR VGND sky130_fd_sc_hd__clkbuf_4
Xload_slew144 VPWR VGND load_slew144/X fanout143/X VPWR VGND sky130_fd_sc_hd__buf_4
X_2075_ VGND VPWR VPWR VGND _2407_/D _2407_/Q _2076_/S _2465_/Q sky130_fd_sc_hd__mux2_1
X_1859_ VGND VPWR VGND VPWR _1858_/Y _1930_/B _2519_/D _1857_/Y sky130_fd_sc_hd__o21ai_0
X_1928_ VGND VPWR VGND VPWR _1927_/Y _1930_/B _2542_/D _1926_/Y sky130_fd_sc_hd__o21ai_0
XFILLER_69_281 VPWR VGND VPWR VGND sky130_fd_sc_hd__decap_8
X_1713_ VPWR VGND VGND VPWR _2125_/A _1755_/B sky130_fd_sc_hd__inv_1
X_1575_ VPWR VGND VGND VPWR _1575_/C _1578_/C _1977_/B _2621_/D sky130_fd_sc_hd__nor3_1
X_1644_ VPWR VGND VGND VPWR _1246_/Y _2465_/D _1643_/Y _2384_/S sky130_fd_sc_hd__mux2i_1
X_2127_ VPWR VGND VGND VPWR _2128_/C _2388_/Q _2446_/Q _2389_/Q _2447_/Q sky130_fd_sc_hd__nor4_1
XPHY_EDGE_ROW_16_Left_87 VPWR VGND VPWR VGND sky130_fd_sc_hd__decap_3
X_2058_ VGND VPWR VPWR VGND _2390_/D hold368/X _2076_/S _2448_/Q sky130_fd_sc_hd__mux2_1
XFILLER_1_225 VPWR VGND VPWR VGND sky130_fd_sc_hd__decap_8
XFILLER_25_181 VGND VPWR VPWR VGND sky130_fd_sc_hd__decap_12
X_1360_ VPWR VGND VPWR VGND _1470_/C _2159_/A _1357_/Y _1371_/A sky130_fd_sc_hd__a21oi_1
X_1291_ VPWR VGND VGND VPWR _2475_/Q _1289_/X _2474_/Q _1291_/Y _1274_/Y _1290_/Y
+ sky130_fd_sc_hd__o32ai_1
X_1558_ VPWR VGND VGND VPWR _2082_/A _1558_/Y _2442_/Q sky130_fd_sc_hd__nand2_1
X_1627_ VPWR VGND VGND VPWR _1627_/A _1627_/Y _2458_/Q sky130_fd_sc_hd__nand2_1
X_1489_ VPWR VGND VGND VPWR _1484_/A _1490_/B _2351_/A _1484_/B _1530_/A sky130_fd_sc_hd__o211ai_1
XFILLER_22_151 VGND VPWR VPWR VGND sky130_fd_sc_hd__decap_4
XFILLER_7_3 VPWR VGND VPWR VGND sky130_fd_sc_hd__decap_8
Xhold380 hold380/X _2590_/Q VPWR VGND VGND VPWR sky130_fd_sc_hd__dlygate4sd3_1
XFILLER_60_224 VGND VPWR VPWR VGND sky130_fd_sc_hd__decap_4
X_2530_ VGND VPWR VPWR VGND clkload8/A _2530_/D load_slew170/X _2530_/Q sky130_fd_sc_hd__dfrtp_1
XFILLER_9_133 VPWR VGND VPWR VGND sky130_fd_sc_hd__decap_6
XFILLER_9_199 VPWR VGND VPWR VGND sky130_fd_sc_hd__decap_8
X_2461_ VGND VPWR VPWR VGND clkload9/A _2461_/D load_slew166/X _2461_/Q sky130_fd_sc_hd__dfrtp_1
X_2392_ VGND VPWR VPWR VGND _2592_/CLK _2392_/D load_slew154/X _2392_/Q sky130_fd_sc_hd__dfrtp_1
X_1412_ VGND VPWR VGND VPWR _1413_/C _1412_/A _1415_/B sky130_fd_sc_hd__or2_0
X_1343_ VGND VPWR VPWR VGND _1343_/X _1484_/A _2159_/A sky130_fd_sc_hd__and2_0
X_1274_ VGND VPWR _1274_/B _1274_/Y _1274_/A VPWR VGND sky130_fd_sc_hd__xnor2_1
Xwire36 VGND VPWR VPWR VGND wire36/A wire36/X sky130_fd_sc_hd__clkdlybuf4s25_1
Xfanout178 VGND VPWR VGND VPWR wire181/A fanout178/X sky130_fd_sc_hd__clkdlybuf4s50_1
Xfanout134 VGND VPWR VGND VPWR _2426_/Q _2198_/B sky130_fd_sc_hd__clkdlybuf4s50_1
Xfanout167 VGND VPWR VGND VPWR fanout173/X fanout167/X sky130_fd_sc_hd__clkdlybuf4s50_1
Xfanout101 VGND VPWR VGND VPWR _2365_/B1 _2173_/A sky130_fd_sc_hd__clkdlybuf4s50_1
Xfanout123 VGND VPWR VGND VPWR _2432_/Q _2242_/A sky130_fd_sc_hd__clkdlybuf4s50_1
Xfanout156 VGND VPWR VGND VPWR fanout192/X fanout156/X sky130_fd_sc_hd__clkdlybuf4s50_1
Xfanout145 VGND VPWR VGND VPWR fanout192/X fanout145/X sky130_fd_sc_hd__clkdlybuf4s50_1
Xfanout112 VGND VPWR VGND VPWR _2351_/A _2159_/A sky130_fd_sc_hd__clkdlybuf4s50_1
XPHY_EDGE_ROW_19_Left_90 VPWR VGND VPWR VGND sky130_fd_sc_hd__decap_3
XFILLER_18_243 VPWR VGND VPWR VGND sky130_fd_sc_hd__decap_8
X_1961_ VGND VPWR VGND VPWR _1960_/Y _1966_/B _1961_/Y _1959_/Y sky130_fd_sc_hd__o21ai_0
X_1892_ VGND VPWR VGND VPWR _1891_/Y _1966_/B _1892_/Y _1890_/Y sky130_fd_sc_hd__o21ai_0
X_2513_ VGND VPWR VPWR VGND clkload8/A _2513_/D load_slew170/X _2513_/Q sky130_fd_sc_hd__dfrtp_1
Xclkbuf_leaf_5_clk VGND VPWR VGND VPWR clkload0/A _2607_/CLK sky130_fd_sc_hd__clkbuf_16
X_2444_ VGND VPWR VPWR VGND _2606_/CLK _2444_/D fanout169/X _2444_/Q sky130_fd_sc_hd__dfrtp_1
X_1326_ VGND VPWR VGND VPWR _1486_/A _2272_/A _1339_/B sky130_fd_sc_hd__or2_0
X_2375_ VPWR VGND VGND VPWR _2379_/A _2375_/B _2375_/Y _2375_/C sky130_fd_sc_hd__nand3_1
X_1257_ VPWR VGND VGND VPWR _2417_/Q _1257_/Y sky130_fd_sc_hd__inv_1
XPHY_EDGE_ROW_4_Left_75 VPWR VGND VPWR VGND sky130_fd_sc_hd__decap_3
X_2160_ VGND VPWR VGND VPWR _2158_/Y _2330_/B _2160_/Y _2486_/Q sky130_fd_sc_hd__o21ai_0
XFILLER_0_97 VGND VPWR VPWR VGND sky130_fd_sc_hd__decap_12
X_2091_ VPWR VGND VGND VPWR _2080_/Y _2090_/X _2413_/D _2078_/Y hold370/X sky130_fd_sc_hd__o2bb2ai_1
X_1875_ VPWR VGND VGND VPWR hold376/X _1875_/Y _2598_/Q _1917_/S sky130_fd_sc_hd__mux2i_1
X_1944_ VPWR VGND VGND VPWR _1942_/A _1944_/Y _2573_/Q _1944_/S sky130_fd_sc_hd__mux2i_1
X_2427_ VPWR VGND VPWR VGND _2427_/Q fanout187/A _2427_/D _2633_/CLK sky130_fd_sc_hd__dfstp_2
XFILLER_0_109 VPWR VGND VPWR VGND sky130_fd_sc_hd__decap_3
X_1309_ VGND VPWR _2255_/A _1311_/A _2230_/A VPWR VGND sky130_fd_sc_hd__xnor2_1
X_2358_ VPWR VGND VPWR VGND _2356_/Y _2351_/B _2357_/Y _2358_/Y sky130_fd_sc_hd__a21oi_1
X_2289_ VGND VPWR _2289_/B _2290_/C _2289_/A VPWR VGND sky130_fd_sc_hd__xnor2_1
X_1660_ VPWR VGND VGND VPWR _2474_/Q _1680_/B _1678_/B sky130_fd_sc_hd__nand2_1
Xhold209 _1966_/A _2555_/Q VPWR VGND VGND VPWR sky130_fd_sc_hd__dlygate4sd3_1
X_1591_ VPWR VGND VGND VPWR _1591_/C _1594_/C _1603_/A _2627_/D sky130_fd_sc_hd__nor3_1
Xload_slew189 VPWR VGND fanout187/A fanout188/X VPWR VGND sky130_fd_sc_hd__buf_4
X_2143_ VPWR VGND VPWR VGND _2213_/B _1680_/A _2143_/Y _2230_/B _2201_/C sky130_fd_sc_hd__a22oi_1
X_2212_ VPWR VGND VGND VPWR _2257_/B _2212_/B _2234_/A sky130_fd_sc_hd__nor2_1
Xload_slew81 VGND VPWR _1672_/B _1466_/B VPWR VGND sky130_fd_sc_hd__clkbuf_4
Xload_slew70 VGND VPWR _1974_/S _1971_/S VPWR VGND sky130_fd_sc_hd__clkbuf_4
X_2074_ VGND VPWR VPWR VGND _2406_/D _2406_/Q _2074_/S _2464_/Q sky130_fd_sc_hd__mux2_1
Xfanout3 VGND VPWR VGND VPWR _2136_/Y fanout3/X sky130_fd_sc_hd__clkdlybuf4s50_1
X_1858_ VPWR VGND VGND VPWR _1858_/A _1858_/Y _1930_/B sky130_fd_sc_hd__nand2_1
X_1927_ VPWR VGND VGND VPWR _1927_/A _1927_/Y _1930_/B sky130_fd_sc_hd__nand2_1
X_1789_ VGND VPWR VPWR VGND _1789_/A _1789_/X _1789_/B sky130_fd_sc_hd__xor2_1
XFILLER_39_48 VGND VPWR VPWR VGND sky130_fd_sc_hd__decap_4
XFILLER_55_69 VPWR VGND VPWR VGND sky130_fd_sc_hd__decap_3
XFILLER_29_157 VPWR VGND VPWR VGND sky130_fd_sc_hd__decap_3
X_1643_ VPWR VGND VGND VPWR _2379_/A _1643_/Y _2466_/Q sky130_fd_sc_hd__nand2_1
X_1712_ VPWR VGND VGND VPWR _2459_/Q _2401_/Q _2125_/A sky130_fd_sc_hd__nor2_1
XFILLER_58_208 VPWR VGND VPWR VGND sky130_fd_sc_hd__decap_6
X_1574_ VPWR VGND VPWR VGND _1573_/C _2620_/Q _2621_/Q _1575_/C sky130_fd_sc_hd__a21oi_1
X_2057_ VGND VPWR VPWR VGND _2389_/D _2389_/Q _2060_/S _2447_/Q sky130_fd_sc_hd__mux2_1
X_2126_ VPWR VGND VPWR VGND _2126_/A _2126_/C _2126_/D _2129_/B _2126_/B sky130_fd_sc_hd__nand4_1
XFILLER_25_193 VGND VPWR VPWR VGND sky130_fd_sc_hd__decap_4
XFILLER_15_83 VPWR VGND VPWR VGND sky130_fd_sc_hd__decap_3
X_1290_ VPWR VGND VPWR VGND _1289_/C _1289_/A _1289_/B _1290_/Y sky130_fd_sc_hd__a21oi_1
XFILLER_0_281 VPWR VGND VPWR VGND sky130_fd_sc_hd__decap_8
XFILLER_31_185 VPWR VGND VPWR VGND sky130_fd_sc_hd__decap_3
X_1626_ VPWR VGND VGND VPWR _1228_/Y _2456_/D _1625_/Y _1628_/S sky130_fd_sc_hd__mux2i_1
X_1557_ VPWR VGND VPWR VGND _1557_/A _1560_/B _2168_/B _1563_/B _2096_/A sky130_fd_sc_hd__nand4_1
X_1488_ VGND VPWR _1490_/A _1488_/Y _1488_/A VPWR VGND sky130_fd_sc_hd__xnor2_1
X_2109_ VPWR VGND _2109_/X _2108_/C _2108_/B _2105_/A _1257_/Y VGND VPWR sky130_fd_sc_hd__a31o_1
XFILLER_52_37 VPWR VGND VPWR VGND sky130_fd_sc_hd__decap_8
XFILLER_22_141 VGND VPWR VPWR VGND sky130_fd_sc_hd__decap_4
Xhold370 hold370/X _2413_/Q VPWR VGND VGND VPWR sky130_fd_sc_hd__dlygate4sd3_1
Xhold381 hold381/X _2441_/Q VPWR VGND VGND VPWR sky130_fd_sc_hd__dlygate4sd3_1
X_2460_ VGND VPWR VPWR VGND clkload9/A _2460_/D load_slew166/X _2460_/Q sky130_fd_sc_hd__dfrtp_1
X_1273_ VGND VPWR VPWR VGND _2176_/A _1274_/B _1391_/B sky130_fd_sc_hd__xor2_1
X_1411_ VGND VPWR VPWR VGND _1413_/C _2331_/B _2159_/A sky130_fd_sc_hd__and2_0
X_2391_ VGND VPWR VPWR VGND clkload2/A _2391_/D load_slew154/X _2391_/Q sky130_fd_sc_hd__dfrtp_1
X_1342_ VGND VPWR VGND VPWR _2272_/A _1484_/A _1342_/Y _2257_/A sky130_fd_sc_hd__o21ai_0
Xwire59 VGND VPWR wire59/X wire60/X VPWR VGND sky130_fd_sc_hd__clkbuf_1
Xwire37 VGND VPWR VPWR VGND wire37/A wire37/X sky130_fd_sc_hd__clkdlybuf4s25_1
Xfanout113 VGND VPWR VGND VPWR _2436_/Q _2351_/A sky130_fd_sc_hd__clkdlybuf4s50_1
Xfanout102 VGND VPWR VGND VPWR _2608_/Q _2365_/B1 sky130_fd_sc_hd__clkdlybuf4s50_1
X_1609_ VPWR VGND VGND VPWR _1627_/A _1609_/Y _2449_/Q sky130_fd_sc_hd__nand2_1
X_2589_ VGND VPWR VPWR VGND clkload2/A _2589_/D fanout151/X _2589_/Q sky130_fd_sc_hd__dfrtp_1
Xfanout135 VGND VPWR VGND VPWR _2426_/Q _1391_/B sky130_fd_sc_hd__clkdlybuf4s50_1
Xfanout124 VGND VPWR VGND VPWR _2230_/A _2283_/A sky130_fd_sc_hd__clkdlybuf4s50_1
Xfanout146 VGND VPWR VGND VPWR fanout148/X fanout146/X sky130_fd_sc_hd__clkdlybuf4s50_1
Xfanout157 VGND VPWR VGND VPWR fanout157/A fanout157/X sky130_fd_sc_hd__clkdlybuf4s50_1
XFILLER_33_236 VPWR VGND VPWR VGND sky130_fd_sc_hd__decap_8
XFILLER_33_203 VGND VPWR VPWR VGND sky130_fd_sc_hd__decap_4
X_1960_ VPWR VGND VGND VPWR _1960_/A _1960_/Y _1966_/B sky130_fd_sc_hd__nand2_1
XFILLER_53_80 VGND VPWR VPWR VGND sky130_fd_sc_hd__decap_4
X_1891_ VPWR VGND VGND VPWR _1891_/A _1891_/Y _1969_/B sky130_fd_sc_hd__nand2_1
XFILLER_52_3 VGND VPWR VPWR VGND sky130_fd_sc_hd__decap_4
X_2512_ VGND VPWR VPWR VGND _2606_/CLK _2512_/D load_slew170/X _2512_/Q sky130_fd_sc_hd__dfrtp_1
X_2443_ VGND VPWR VPWR VGND _2606_/CLK _2443_/D fanout169/X _2443_/Q sky130_fd_sc_hd__dfrtp_1
X_1256_ VPWR VGND VGND VPWR _2173_/A _1256_/Y sky130_fd_sc_hd__inv_1
X_1325_ VPWR VGND VGND VPWR _2272_/A _1486_/A _1485_/A sky130_fd_sc_hd__nor2_1
X_2374_ VGND VPWR VGND VPWR _2373_/Y _1455_/Y _2441_/D _2373_/B sky130_fd_sc_hd__o21ai_0
XPHY_EDGE_ROW_20_Left_91 VPWR VGND VPWR VGND sky130_fd_sc_hd__decap_3
X_2090_ VGND VPWR VPWR VGND _2413_/Q _2090_/X _2090_/B sky130_fd_sc_hd__xor2_1
XFILLER_65_169 VGND VPWR VPWR VGND sky130_fd_sc_hd__decap_4
X_1943_ VGND VPWR VGND VPWR _1942_/Y _1942_/B _2547_/D _1941_/Y sky130_fd_sc_hd__o21ai_0
X_1874_ VGND VPWR VGND VPWR _1873_/Y _1945_/B _2524_/D _1872_/Y sky130_fd_sc_hd__o21ai_0
X_2426_ VPWR VGND VPWR VGND _2426_/Q fanout187/X _2426_/D _2633_/CLK sky130_fd_sc_hd__dfstp_2
XFILLER_56_169 VPWR VGND VPWR VGND sky130_fd_sc_hd__decap_3
X_1239_ VPWR VGND VGND VPWR _2445_/Q _1239_/Y sky130_fd_sc_hd__inv_1
X_1308_ VPWR VGND VGND VPWR _2230_/A _1308_/Y _2255_/A sky130_fd_sc_hd__nand2_1
X_2357_ VGND VPWR VGND VPWR _2360_/A _2316_/B _2357_/Y _2351_/B sky130_fd_sc_hd__o21ai_0
X_2288_ VPWR VGND VGND VPWR _2483_/Q _2288_/Y _2289_/B sky130_fd_sc_hd__nand2_1
XFILLER_60_15 VPWR VGND VPWR VGND sky130_fd_sc_hd__decap_3
X_1590_ VPWR VGND VPWR VGND _1589_/C _2626_/Q _2627_/Q _1591_/C sky130_fd_sc_hd__a21oi_1
Xload_slew179 VGND VPWR fanout178/X _2494_/SET_B VPWR VGND sky130_fd_sc_hd__clkbuf_4
X_2142_ VPWR VGND VGND VPWR _2213_/B _1680_/A _2191_/A _2141_/Y _2142_/Y sky130_fd_sc_hd__o22ai_1
X_2073_ VGND VPWR VPWR VGND _2405_/D hold360/X _2074_/S _2463_/Q sky130_fd_sc_hd__mux2_1
X_2211_ VPWR VGND VGND VPWR _2176_/A _2211_/Y _2475_/Q _2286_/S sky130_fd_sc_hd__mux2i_1
Xload_slew168 VGND VPWR fanout167/X load_slew168/X VPWR VGND sky130_fd_sc_hd__clkbuf_4
X_1788_ VPWR VGND VGND VPWR _1789_/B _1788_/C _2465_/Q _2407_/Q sky130_fd_sc_hd__maj3_1
X_1857_ VPWR VGND VGND VPWR _2518_/Q _1857_/Y _2592_/Q _1926_/S sky130_fd_sc_hd__mux2i_1
X_1926_ VPWR VGND VGND VPWR _2541_/Q _1926_/Y _2567_/Q _1926_/S sky130_fd_sc_hd__mux2i_1
X_2409_ VGND VPWR VPWR VGND _2592_/CLK _2409_/D fanout148/X _2409_/Q sky130_fd_sc_hd__dfrtp_1
XFILLER_55_37 VGND VPWR VPWR VGND sky130_fd_sc_hd__decap_4
XFILLER_29_169 VPWR VGND VPWR VGND sky130_fd_sc_hd__decap_6
XPHY_EDGE_ROW_33_Left_104 VPWR VGND VPWR VGND sky130_fd_sc_hd__decap_3
XPHY_EDGE_ROW_42_Left_113 VPWR VGND VPWR VGND sky130_fd_sc_hd__decap_3
XFILLER_4_213 VPWR VGND VPWR VGND sky130_fd_sc_hd__decap_8
XFILLER_35_106 VPWR VGND VPWR VGND sky130_fd_sc_hd__decap_3
XPHY_EDGE_ROW_51_Left_122 VPWR VGND VPWR VGND sky130_fd_sc_hd__decap_3
X_1642_ VPWR VGND VGND VPWR _1245_/Y _2464_/D _1641_/Y _2384_/S sky130_fd_sc_hd__mux2i_1
X_1711_ VPWR VGND VGND VPWR _2123_/B _1749_/A _1756_/A sky130_fd_sc_hd__nand2_1
XPHY_EDGE_ROW_60_Left_131 VPWR VGND VPWR VGND sky130_fd_sc_hd__decap_3
X_1573_ VGND VPWR _1578_/C _2620_/Q _2621_/Q _1573_/C VPWR VGND sky130_fd_sc_hd__and3_1
XFILLER_66_253 VPWR VGND VPWR VGND sky130_fd_sc_hd__decap_6
X_2125_ VPWR VGND VPWR VGND _2125_/A _2125_/C _2125_/D _2129_/A _2125_/B sky130_fd_sc_hd__nand4_1
X_2056_ VGND VPWR VPWR VGND _2388_/D _2388_/Q _2074_/S _2446_/Q sky130_fd_sc_hd__mux2_1
XFILLER_19_191 VGND VPWR VPWR VGND sky130_fd_sc_hd__decap_12
X_1909_ VPWR VGND VGND VPWR _1909_/A _1909_/Y _1909_/B sky130_fd_sc_hd__nand2_1
XFILLER_66_58 VGND VPWR VPWR VGND sky130_fd_sc_hd__decap_12
XFILLER_66_25 VPWR VGND VPWR VGND sky130_fd_sc_hd__decap_3
XFILLER_40_197 VPWR VGND VPWR VGND sky130_fd_sc_hd__decap_3
XFILLER_16_161 VPWR VGND VPWR VGND sky130_fd_sc_hd__decap_6
X_1556_ VPWR VGND VGND VPWR _1556_/A _1556_/B _2168_/B wire59/X sky130_fd_sc_hd__nand3_1
X_1625_ VPWR VGND VGND VPWR _1627_/A _1625_/Y _2457_/Q sky130_fd_sc_hd__nand2_1
X_1487_ VPWR VGND VGND VPWR _2316_/B _1487_/Y _1470_/B _1484_/B _1490_/A sky130_fd_sc_hd__o211ai_1
X_2039_ VPWR VGND VPWR VGND _2038_/B _1224_/Y _2038_/Y _2601_/D sky130_fd_sc_hd__a21oi_1
X_2108_ VPWR VGND VGND VPWR _2108_/A _2108_/B _2108_/Y _2108_/C sky130_fd_sc_hd__nand3_1
Xhold360 hold360/X _2405_/Q VPWR VGND VGND VPWR sky130_fd_sc_hd__dlygate4sd3_1
Xhold371 hold371/X _2403_/Q VPWR VGND VGND VPWR sky130_fd_sc_hd__dlygate4sd3_1
X_1410_ VPWR VGND VGND VPWR _1412_/A _1415_/A _1413_/B sky130_fd_sc_hd__nor2_1
X_1272_ VPWR VGND VGND VPWR _2212_/B _1289_/A _2137_/A sky130_fd_sc_hd__nand2_1
X_1341_ VPWR VGND VGND VPWR _1341_/A _1341_/Y _1341_/B sky130_fd_sc_hd__nand2_1
X_2390_ VGND VPWR VPWR VGND clkload2/A _2390_/D load_slew154/X _2390_/Q sky130_fd_sc_hd__dfrtp_1
XFILLER_36_212 VPWR VGND VPWR VGND sky130_fd_sc_hd__decap_6
Xwire16 VGND VPWR wire16/X wire16/A VPWR VGND sky130_fd_sc_hd__buf_1
Xfanout136 VGND VPWR VGND VPWR _2425_/Q _2185_/B sky130_fd_sc_hd__clkdlybuf4s50_1
X_1539_ VPWR VGND VGND VPWR locked wire72/A _1539_/B sky130_fd_sc_hd__nand2_1
Xfanout125 VGND VPWR VGND VPWR _2431_/Q _2230_/A sky130_fd_sc_hd__clkdlybuf4s50_1
X_2588_ VGND VPWR VPWR VGND clkload8/A _2588_/D load_slew168/X _2588_/Q sky130_fd_sc_hd__dfrtp_1
X_1608_ VPWR VGND VGND VPWR _1237_/Y _2447_/D _1607_/Y _1638_/S sky130_fd_sc_hd__mux2i_1
Xfanout114 VGND VPWR VGND VPWR _2331_/A _1484_/A sky130_fd_sc_hd__clkdlybuf4s50_1
Xfanout169 VGND VPWR VGND VPWR fanout171/X fanout169/X sky130_fd_sc_hd__clkdlybuf4s50_1
XPHY_EDGE_ROW_16_Right_16 VPWR VGND VPWR VGND sky130_fd_sc_hd__decap_3
X_1890_ VPWR VGND VGND VPWR _2529_/Q _1890_/Y _2603_/Q _1902_/S sky130_fd_sc_hd__mux2i_1
XFILLER_41_281 VPWR VGND VPWR VGND sky130_fd_sc_hd__decap_8
XPHY_EDGE_ROW_25_Right_25 VPWR VGND VPWR VGND sky130_fd_sc_hd__decap_3
X_2511_ VGND VPWR VPWR VGND _2606_/CLK _2511_/D _2429_/SET_B _2511_/Q sky130_fd_sc_hd__dfrtp_1
XFILLER_45_3 VPWR VGND VPWR VGND sky130_fd_sc_hd__decap_8
X_2442_ VGND VPWR VPWR VGND _2592_/CLK _2442_/D fanout157/A _2442_/Q sky130_fd_sc_hd__dfrtp_1
X_2373_ VPWR VGND VGND VPWR _2373_/A _2373_/Y _2373_/B sky130_fd_sc_hd__nand2_1
XPHY_EDGE_ROW_34_Right_34 VPWR VGND VPWR VGND sky130_fd_sc_hd__decap_3
X_1324_ VPWR VGND VGND VPWR _2272_/A _1339_/A _1486_/A sky130_fd_sc_hd__nand2_1
X_1255_ VPWR VGND VGND VPWR _2470_/Q _1255_/Y sky130_fd_sc_hd__inv_1
XPHY_EDGE_ROW_43_Right_43 VPWR VGND VPWR VGND sky130_fd_sc_hd__decap_3
XPHY_EDGE_ROW_52_Right_52 VPWR VGND VPWR VGND sky130_fd_sc_hd__decap_3
XPHY_EDGE_ROW_61_Right_61 VPWR VGND VPWR VGND sky130_fd_sc_hd__decap_3
XPHY_EDGE_ROW_70_Right_70 VPWR VGND VPWR VGND sky130_fd_sc_hd__decap_3
XFILLER_0_33 VGND VPWR VPWR VGND sky130_fd_sc_hd__decap_12
X_1942_ VPWR VGND VGND VPWR _1942_/A _1942_/Y _1942_/B sky130_fd_sc_hd__nand2_1
X_1873_ VPWR VGND VGND VPWR _1873_/A _1873_/Y _1945_/B sky130_fd_sc_hd__nand2_1
X_2425_ VPWR VGND VPWR VGND _2425_/Q fanout190/X _2425_/D _2616_/CLK sky130_fd_sc_hd__dfstp_2
X_2356_ VGND VPWR _2356_/B _2356_/Y _2356_/A VPWR VGND sky130_fd_sc_hd__xnor2_1
XFILLER_64_192 VGND VPWR VPWR VGND sky130_fd_sc_hd__decap_4
X_1307_ VGND VPWR VPWR VGND _1297_/Y _1296_/Y _1292_/X _1307_/Y _1306_/Y sky130_fd_sc_hd__a31oi_1
X_1238_ VPWR VGND VGND VPWR _2446_/Q _1238_/Y sky130_fd_sc_hd__inv_1
X_2287_ VGND VPWR _2287_/B _2289_/B _2331_/A VPWR VGND sky130_fd_sc_hd__xnor2_1
X_2210_ VGND VPWR VPWR VGND _2209_/Y _2208_/Y _2136_/B _2426_/D _2196_/Y sky130_fd_sc_hd__a31oi_1
Xload_slew147 VGND VPWR fanout146/X load_slew147/X VPWR VGND sky130_fd_sc_hd__clkbuf_4
Xload_slew158 VPWR VGND _2437_/SET_B fanout157/X VPWR VGND sky130_fd_sc_hd__buf_4
X_2141_ VPWR VGND VPWR VGND _2474_/Q _2137_/A _2140_/X _2141_/Y sky130_fd_sc_hd__a21oi_1
X_2072_ VGND VPWR VPWR VGND _2404_/D _2404_/Q _2074_/S _2462_/Q sky130_fd_sc_hd__mux2_1
X_1925_ VGND VPWR VGND VPWR _1924_/Y _1924_/B _2541_/D _1923_/Y sky130_fd_sc_hd__o21ai_0
X_1787_ VGND VPWR _2408_/Q _1789_/A _2466_/Q VPWR VGND sky130_fd_sc_hd__xnor2_1
X_1856_ VGND VPWR VGND VPWR _1855_/Y _1930_/B _2518_/D _1854_/Y sky130_fd_sc_hd__o21ai_0
Xfanout5 VGND VPWR VGND VPWR _2076_/S _2060_/S sky130_fd_sc_hd__clkdlybuf4s50_1
XFILLER_69_273 VPWR VGND VPWR VGND sky130_fd_sc_hd__decap_6
X_2408_ VGND VPWR VPWR VGND _2607_/CLK _2408_/D wire181/X _2408_/Q sky130_fd_sc_hd__dfrtp_1
XPHY_EDGE_ROW_2_Right_2 VPWR VGND VPWR VGND sky130_fd_sc_hd__decap_3
X_2339_ VGND VPWR VPWR VGND _2339_/A _2339_/X _2339_/B sky130_fd_sc_hd__xor2_1
XFILLER_55_27 VGND VPWR VPWR VGND sky130_fd_sc_hd__decap_4
XFILLER_37_181 VGND VPWR VPWR VGND sky130_fd_sc_hd__decap_12
XFILLER_43_195 VPWR VGND VPWR VGND sky130_fd_sc_hd__decap_6
X_1572_ VPWR VGND VGND VPWR _1977_/B _1572_/B _2620_/D sky130_fd_sc_hd__nor2_1
X_1641_ VPWR VGND VGND VPWR _2383_/A _1641_/Y _2465_/Q sky130_fd_sc_hd__nand2_1
X_1710_ VPWR VGND VGND VPWR _2460_/Q _1756_/A _2402_/Q sky130_fd_sc_hd__nand2_1
X_2124_ VPWR VGND VGND VPWR _2124_/C _2390_/Q _2448_/Q _2125_/D sky130_fd_sc_hd__nor3_1
X_2055_ VGND VPWR VPWR VGND _2387_/D hold366/X _2074_/S _2445_/Q sky130_fd_sc_hd__mux2_1
X_1839_ VPWR VGND VGND VPWR _2512_/Q _1839_/Y _2586_/Q _1956_/S sky130_fd_sc_hd__mux2i_1
X_1908_ VPWR VGND VGND VPWR _2535_/Q _1908_/Y _2561_/Q _1971_/S sky130_fd_sc_hd__mux2i_1
XFILLER_25_140 VGND VPWR VPWR VGND sky130_fd_sc_hd__decap_4
XFILLER_48_265 VGND VPWR VPWR VGND sky130_fd_sc_hd__decap_12
XFILLER_16_151 VPWR VGND VPWR VGND sky130_fd_sc_hd__decap_6
X_1555_ VPWR VGND VGND VPWR wire60/A _1555_/D _2472_/Q _2473_/Q _2474_/Q sky130_fd_sc_hd__nor4_1
X_1624_ VPWR VGND VGND VPWR _1229_/Y _2455_/D _1623_/Y _1624_/S sky130_fd_sc_hd__mux2i_1
XFILLER_54_235 VPWR VGND VPWR VGND sky130_fd_sc_hd__decap_8
XFILLER_39_276 VGND VPWR VPWR VGND sky130_fd_sc_hd__decap_4
X_1486_ VPWR VGND VGND VPWR _1486_/Y _1486_/D _1523_/A _2242_/A _1486_/A sky130_fd_sc_hd__nor4_1
X_2107_ VPWR VGND VPWR VGND _2106_/Y _2105_/Y _2110_/B1 _2416_/D sky130_fd_sc_hd__a21oi_1
X_2038_ VPWR VGND VGND VPWR _2038_/A _2038_/B _2038_/Y sky130_fd_sc_hd__nor2_1
Xhold350 _1978_/A _2560_/Q VPWR VGND VGND VPWR sky130_fd_sc_hd__dlygate4sd3_1
Xhold372 hold372/X _2394_/Q VPWR VGND VGND VPWR sky130_fd_sc_hd__dlygate4sd3_1
Xhold361 hold361/X _2391_/Q VPWR VGND VGND VPWR sky130_fd_sc_hd__dlygate4sd3_1
XFILLER_60_205 VGND VPWR VPWR VGND sky130_fd_sc_hd__decap_12
XFILLER_9_147 VPWR VGND VPWR VGND sky130_fd_sc_hd__decap_6
X_1340_ VPWR VGND VPWR VGND _1340_/A _1340_/C _1341_/B _1340_/Y _1340_/B sky130_fd_sc_hd__nand4_1
X_1271_ VPWR VGND VGND VPWR _2176_/A _2198_/B _1477_/A sky130_fd_sc_hd__nor2_1
Xclkbuf_leaf_8_clk VGND VPWR VGND VPWR clkload0/A _2616_/CLK sky130_fd_sc_hd__clkbuf_16
X_1538_ VGND VPWR VPWR VGND _2633_/D _1603_/A i2s_bclk sky130_fd_sc_hd__and2_0
Xfanout137 VGND VPWR VGND VPWR _2425_/Q _1389_/B sky130_fd_sc_hd__clkdlybuf4s50_1
X_1469_ VPWR VGND VGND VPWR _1472_/A _1469_/Y _1495_/B sky130_fd_sc_hd__nand2_1
X_2587_ VGND VPWR VPWR VGND clkload8/A _2587_/D load_slew172/X _2587_/Q sky130_fd_sc_hd__dfrtp_1
Xfanout126 VGND VPWR VGND VPWR _2257_/B _2255_/A sky130_fd_sc_hd__clkdlybuf4s50_1
X_1607_ VPWR VGND VGND VPWR _2383_/A _1607_/Y _2448_/Q sky130_fd_sc_hd__nand2_1
Xfanout104 VGND VPWR VGND VPWR _2486_/Q _2332_/A sky130_fd_sc_hd__clkdlybuf4s50_1
Xfanout115 VGND VPWR VGND VPWR _2435_/Q _2331_/A sky130_fd_sc_hd__clkdlybuf4s50_1
Xfanout148 VGND VPWR VGND VPWR fanout192/X fanout148/X sky130_fd_sc_hd__clkdlybuf4s50_1
Xfanout159 VGND VPWR VGND VPWR fanout159/A fanout159/X sky130_fd_sc_hd__clkdlybuf4s50_1
XFILLER_27_202 VPWR VGND VPWR VGND sky130_fd_sc_hd__decap_3
XFILLER_5_3 VPWR VGND VPWR VGND sky130_fd_sc_hd__decap_6
X_2510_ VGND VPWR VPWR VGND _2607_/CLK _2510_/D fanout187/A _2510_/Q sky130_fd_sc_hd__dfrtp_1
X_1323_ VGND VPWR VGND VPWR _1322_/Y _1312_/Y _1323_/Y _1317_/Y sky130_fd_sc_hd__o21ai_0
X_2441_ VGND VPWR VPWR VGND _2592_/CLK _2441_/D fanout148/X _2441_/Q sky130_fd_sc_hd__dfrtp_1
X_2372_ VGND VPWR VPWR VGND _2440_/D _2371_/X _2368_/Y _2609_/Q _2369_/Y _2440_/Q
+ sky130_fd_sc_hd__a32o_1
X_1254_ VPWR VGND VGND VPWR _2502_/Q _1254_/Y sky130_fd_sc_hd__inv_1
XFILLER_3_109 VPWR VGND VPWR VGND sky130_fd_sc_hd__decap_3
XFILLER_2_197 VPWR VGND VPWR VGND sky130_fd_sc_hd__decap_8
Xmax_cap4 VGND VPWR _2110_/B1 _2101_/Y VPWR VGND sky130_fd_sc_hd__buf_1
XFILLER_0_45 VPWR VGND VPWR VGND sky130_fd_sc_hd__decap_6
X_1941_ VPWR VGND VGND VPWR _2546_/Q _1941_/Y _2572_/Q _1944_/S sky130_fd_sc_hd__mux2i_1
X_1872_ VPWR VGND VGND VPWR _2523_/Q _1872_/Y _2597_/Q _1917_/S sky130_fd_sc_hd__mux2i_1
X_2424_ VPWR VGND VPWR VGND _2424_/Q fanout190/X _2424_/D _2616_/CLK sky130_fd_sc_hd__dfstp_2
X_1306_ VPWR VGND VGND VPWR _2476_/Q _1296_/B _1305_/Y _2477_/Q _1306_/Y sky130_fd_sc_hd__o22ai_1
X_2286_ VPWR VGND VGND VPWR _2287_/B _2286_/Y _2480_/Q _2286_/S sky130_fd_sc_hd__mux2i_1
X_2355_ VPWR VGND VGND VPWR _2356_/A _2356_/B _2355_/Y sky130_fd_sc_hd__nor2_1
X_1237_ VPWR VGND VGND VPWR _2447_/Q _1237_/Y sky130_fd_sc_hd__inv_1
XFILLER_20_241 VPWR VGND VPWR VGND sky130_fd_sc_hd__decap_6
XPHY_EDGE_ROW_8_Left_79 VPWR VGND VPWR VGND sky130_fd_sc_hd__decap_3
XFILLER_55_160 VGND VPWR VPWR VGND sky130_fd_sc_hd__decap_4
X_2140_ VPWR VGND VGND VPWR _2140_/X _2140_/C _2201_/B _2473_/Q sky130_fd_sc_hd__maj3_1
X_2071_ VGND VPWR VPWR VGND _2403_/D hold371/X _2074_/S _2461_/Q sky130_fd_sc_hd__mux2_1
Xload_slew62 VPWR VGND _1944_/S _1926_/S VPWR VGND sky130_fd_sc_hd__buf_4
XFILLER_61_185 VGND VPWR VPWR VGND sky130_fd_sc_hd__decap_12
X_1855_ VPWR VGND VGND VPWR _1855_/A _1855_/Y _1930_/B sky130_fd_sc_hd__nand2_1
X_1924_ VPWR VGND VGND VPWR _1924_/A _1924_/Y _1924_/B sky130_fd_sc_hd__nand2_1
X_1786_ VPWR VGND VGND VPWR _2466_/Q _1786_/Y _2408_/Q sky130_fd_sc_hd__nand2_1
X_2407_ VGND VPWR VPWR VGND _2607_/CLK _2407_/D wire181/X _2407_/Q sky130_fd_sc_hd__dfrtp_1
X_2269_ VGND VPWR VPWR VGND _1512_/A _2430_/D _1466_/B _2136_/B _2267_/Y _2268_/Y
+ sky130_fd_sc_hd__a32oi_1
XFILLER_29_149 VPWR VGND VPWR VGND sky130_fd_sc_hd__decap_8
XFILLER_29_105 VPWR VGND VPWR VGND sky130_fd_sc_hd__decap_6
X_2338_ VPWR VGND VGND VPWR _2321_/A _2349_/B _2320_/Y _2339_/A _2323_/B sky130_fd_sc_hd__o211ai_1
XFILLER_37_193 VGND VPWR VPWR VGND sky130_fd_sc_hd__decap_4
X_1571_ VGND VPWR _1573_/C _1572_/B _2620_/Q VPWR VGND sky130_fd_sc_hd__xnor2_1
X_1640_ VPWR VGND VGND VPWR _1244_/Y _2463_/D _1639_/Y _2384_/S sky130_fd_sc_hd__mux2i_1
XFILLER_3_281 VPWR VGND VPWR VGND sky130_fd_sc_hd__decap_8
XFILLER_3_270 VPWR VGND VPWR VGND sky130_fd_sc_hd__decap_8
X_2123_ VPWR VGND VGND VPWR _2443_/Q _2123_/B _2125_/C sky130_fd_sc_hd__nor2_1
XFILLER_20_3 VGND VPWR VPWR VGND sky130_fd_sc_hd__decap_4
X_2054_ VGND VPWR VPWR VGND _2386_/D hold365/X _2054_/S _2444_/Q sky130_fd_sc_hd__mux2_1
X_1838_ VGND VPWR VGND VPWR _1837_/Y _1909_/B _2512_/D _1836_/Y sky130_fd_sc_hd__o21ai_0
X_1907_ VGND VPWR VGND VPWR _1906_/Y _1909_/B _1907_/Y _1905_/Y sky130_fd_sc_hd__o21ai_0
X_1769_ VPWR VGND VPWR VGND _1760_/Y _1763_/A _2119_/B _1770_/B sky130_fd_sc_hd__a21oi_1
XFILLER_48_277 VGND VPWR VPWR VGND sky130_fd_sc_hd__decap_12
XFILLER_48_222 VGND VPWR VPWR VGND sky130_fd_sc_hd__decap_4
XFILLER_63_225 VGND VPWR VPWR VGND sky130_fd_sc_hd__decap_12
X_1554_ VPWR VGND VPWR VGND _1688_/A _2201_/C _1680_/A _1555_/D _2200_/A sky130_fd_sc_hd__nand4_1
X_1485_ VPWR VGND VGND VPWR _1485_/A _1485_/B _1490_/A _1523_/B sky130_fd_sc_hd__nand3_1
X_1623_ VPWR VGND VGND VPWR _1627_/A _1623_/Y _2456_/Q sky130_fd_sc_hd__nand2_1
.ends

.subckt tt_um_spdif_to_i2s_kilpelaj clk ena rst_n ua[0] ua[1] ua[2] ua[3] ua[4] ua[5]
+ ua[6] ua[7] ui_in[0] ui_in[1] ui_in[2] ui_in[3] ui_in[4] ui_in[5] ui_in[6] ui_in[7]
+ uio_in[0] uio_in[1] uio_in[2] uio_in[3] uio_in[4] uio_in[5] uio_in[6] uio_in[7]
+ uo_out[0] uo_out[1] uo_out[2] uo_out[3] uo_out[4] uo_out[5] uo_out[6] uo_out[7]
+ VDPWR VGND
XM10 VGND VGND M8/G M9/G VGND sky130_fd_pr__nfet_01v8_GT9DNQ
XM11 VDPWR VDPWR M9/G M14/G VDPWR M14/G VDPWR sky130_fd_pr__pfet_01v8_99L4LZ
XM13 VDPWR VDPWR M14/G uo_out[6] VDPWR uo_out[6] VDPWR sky130_fd_pr__pfet_01v8_99L4LZ
XM12 VGND VGND M6/G M14/G VGND sky130_fd_pr__nfet_01v8_U5JGNU
XM14 VGND VGND M14/G uo_out[6] VGND sky130_fd_pr__nfet_01v8_U5JGNU
XM1 VGND M1/D VGND M4/S sky130_fd_pr__nfet_01v8_8UCVU5
XM17 VGND VGND M19/D ua[0] VGND ua[0] VGND ua[0] VGND ua[0] VGND ua[0] VGND sky130_fd_pr__nfet_01v8_ST42GL
XM2 VGND M1/D ua[0] M8/G M1/D sky130_fd_pr__nfet_01v8_GT9DNQ
XM18 VDPWR M19/D VDPWR uo_out[3] sky130_fd_pr__pfet_01v8_TPLPJ6
XM4 VGND VGND M4/S M4/S sky130_fd_pr__nfet_01v8_8UCVU5
XM3 VGND M1/D M3/G M6/G M1/D sky130_fd_pr__nfet_01v8_GT9DNQ
Xsky130_fd_pr__res_xhigh_po_0p69_3D2XQL_0 VGND M3/G VGND M3/G VDPWR VDPWR sky130_fd_pr__res_xhigh_po_0p69_3D2XQL_0/R2_3
+ M4/S sky130_fd_pr__res_xhigh_po_0p69_3D2XQL_0/R2_3 sky130_fd_pr__res_xhigh_po_0p69_3D2XQL
XM5 VDPWR VDPWR M6/G M8/G VDPWR M8/G VDPWR M8/G VDPWR sky130_fd_pr__pfet_01v8_U6MDYH
XM19 VGND M19/D VGND uo_out[3] sky130_fd_pr__nfet_01v8_DSPFQQ
XM6 VDPWR VDPWR M6/G M6/G VDPWR sky130_fd_pr__pfet_01v8_S8FMYS
XM7 VDPWR VDPWR M8/G M6/G VDPWR M6/G VDPWR M6/G VDPWR sky130_fd_pr__pfet_01v8_E4RPCE
XM8 VDPWR VDPWR M8/G M8/G VDPWR sky130_fd_pr__pfet_01v8_S8FMYS
XM9 VDPWR VDPWR M9/G M9/G VDPWR M9/G VDPWR sky130_fd_pr__pfet_01v8_QR4GC9
Xspdif_to_i2s_0 VDPWR uo_out[5] clk uo_out[0] uo_out[2] uo_out[1] uo_out[4] uo_out[3]
+ uo_out[7] rst_n ui_in[0] VGND spdif_to_i2s
.ends
